* Current baseline sample
.param M4_vth0 = 9.925446280716e-01
.param M4_u0 = 9.612826686042e-01
.param M4_voff = 9.512312114854e-01
.param M5_vth0 = 1.102619139950e+00
.param M5_u0 = 1.050415960625e+00
.param M5_voff = 1.022987180523e+00
.param M9_vth0 = 1.053051607206e+00
.param M9_u0 = 9.841187823228e-01
.param M9_voff = 1.004210395902e+00
.param M11_vth0 = 1.010409351743e+00
.param M11_u0 = 9.379768262586e-01
.param M11_voff = 1.021294430045e+00
.param M15_vth0 = 9.718249952485e-01
.param M15_u0 = 1.032220787962e+00
.param M15_voff = 9.704195333207e-01
.param M17_vth0 = 9.580179328995e-01
.param M17_u0 = 1.066820402670e+00
.param M17_voff = 1.069627492762e+00
.param M18_vth0 = 9.661757416819e-01
.param M18_u0 = 9.349075322453e-01
.param M18_voff = 9.661228700515e-01
.param M19_vth0 = 9.812905156763e-01
.param M19_u0 = 1.084398663349e+00
.param M19_voff = 9.180469681859e-01
.param M22_vth0 = 9.872465339865e-01
.param M22_u0 = 1.036247301812e+00
.param M22_voff = 9.912384895877e-01
.param M24_vth0 = 1.021789286087e+00
.param M24_u0 = 1.036137260161e+00
.param M24_voff = 1.001012263234e+00
.param M26_vth0 = 1.041755010256e+00
.param M26_u0 = 1.009734923194e+00
.param M26_voff = 1.017354732869e+00
.param M28_vth0 = 1.021350012426e+00
.param M28_u0 = 1.017382769230e+00
.param M28_voff = 1.009818096046e+00
.param M30_vth0 = 9.111590579703e-01
.param M30_u0 = 1.026458273321e+00
.param M30_voff = 1.098520877855e+00
.param M32_vth0 = 8.980095261488e-01
.param M32_u0 = 9.730349894515e-01
.param M32_voff = 9.200536444811e-01
.param M34_vth0 = 1.053841683126e+00
.param M34_u0 = 1.025901752677e+00
.param M34_voff = 9.413066139620e-01
.param M36_vth0 = 9.707236228001e-01
.param M36_u0 = 9.929513980882e-01
.param M36_voff = 9.363365741849e-01
.param M38_vth0 = 9.173014159827e-01
.param M38_u0 = 1.032065381389e+00
.param M38_voff = 1.096279239356e+00
.param M40_vth0 = 9.983578513300e-01
.param M40_u0 = 1.025441026131e+00
.param M40_voff = 1.038275722657e+00
.param M42_vth0 = 1.029859836353e+00
.param M42_u0 = 9.349104944179e-01
.param M42_voff = 1.015456655869e+00
.param M44_vth0 = 9.894508666092e-01
.param M44_u0 = 9.898032118648e-01
.param M44_voff = 1.024594694860e+00
.param M46_vth0 = 9.996891185513e-01
.param M46_u0 = 1.020144851107e+00
.param M46_voff = 1.051926766844e+00
.param M48_vth0 = 9.955318868624e-01
.param M48_u0 = 1.005577621253e+00
.param M48_voff = 1.070496049970e+00
.param M50_vth0 = 1.031817325892e+00
.param M50_u0 = 1.051524537355e+00
.param M50_voff = 1.041774144582e+00
.param M52_vth0 = 1.017172609966e+00
.param M52_u0 = 9.876587137310e-01
.param M52_voff = 1.038326751963e+00
.param M54_vth0 = 9.804024407245e-01
.param M54_u0 = 9.800780375011e-01
.param M54_voff = 9.791023241212e-01
.param M56_vth0 = 1.014215597404e+00
.param M56_u0 = 9.725347707826e-01
.param M56_voff = 9.922474200800e-01
.param M58_vth0 = 1.047340452263e+00
.param M58_u0 = 9.911598410415e-01
.param M58_voff = 1.025976292517e+00
.param M60_vth0 = 9.990500060030e-01
.param M60_u0 = 9.812905236651e-01
.param M60_voff = 9.997511226162e-01
.param M62_vth0 = 1.052372835166e+00
.param M62_u0 = 1.006948507752e+00
.param M62_voff = 1.077880167350e+00
.param M64_vth0 = 9.614031130357e-01
.param M64_u0 = 1.019820413925e+00
.param M64_voff = 9.318119475563e-01
.param M66_vth0 = 1.016239489677e+00
.param M66_u0 = 9.677790840282e-01
.param M66_voff = 1.029148563204e+00
.param M68_vth0 = 9.537458955544e-01
.param M68_u0 = 1.019258192908e+00
.param M68_voff = 1.060819362227e+00
.param M70_vth0 = 9.904237783067e-01
.param M70_u0 = 1.030905448929e+00
.param M70_voff = 9.258065263723e-01
.param M72_vth0 = 8.888938876394e-01
.param M72_u0 = 9.703269358258e-01
.param M72_voff = 9.944461615499e-01
.param M74_vth0 = 1.095279879286e+00
.param M74_u0 = 9.798163081079e-01
.param M74_voff = 1.050110653789e+00
.param M76_vth0 = 1.030608180686e+00
.param M76_u0 = 9.806428311472e-01
.param M76_voff = 1.041876897486e+00
.param M78_vth0 = 1.102819447506e+00
.param M78_u0 = 9.757314400734e-01
.param M78_voff = 1.024784587409e+00
.param M80_vth0 = 9.483462137413e-01
.param M80_u0 = 9.478588802596e-01
.param M80_voff = 1.061280318812e+00
.param M82_vth0 = 9.916496627258e-01
.param M82_u0 = 1.112745258083e+00
.param M82_voff = 1.001809890243e+00
.param M84_vth0 = 1.026265358491e+00
.param M84_u0 = 1.075656898622e+00
.param M84_voff = 9.196032757711e-01
.param M86_vth0 = 9.974526142872e-01
.param M86_u0 = 9.895173836837e-01
.param M86_voff = 1.014018691987e+00
.param M88_vth0 = 9.970335542298e-01
.param M88_u0 = 1.082985753996e+00
.param M88_voff = 9.830274028223e-01
.param M90_vth0 = 1.127376451387e+00
.param M90_u0 = 9.664066537570e-01
.param M90_voff = 9.012902325786e-01
.param M92_vth0 = 1.044462860854e+00
.param M92_u0 = 1.025585108598e+00
.param M92_voff = 9.644012498984e-01
.param M94_vth0 = 1.008414452535e+00
.param M94_u0 = 9.888896122583e-01
.param M94_voff = 9.865670306368e-01
.param M96_vth0 = 9.404240095307e-01
.param M96_u0 = 1.020409301729e+00
.param M96_voff = 1.021460931179e+00
.param M98_vth0 = 1.048395153462e+00
.param M98_u0 = 1.004690403426e+00
.param M98_voff = 1.041241737969e+00
.param M100_vth0 = 1.044829813088e+00
.param M100_u0 = 1.052167368311e+00
.param M100_voff = 9.937245537735e-01
.param M102_vth0 = 9.599541362734e-01
.param M102_u0 = 9.743151273708e-01
.param M102_voff = 1.012042806594e+00
.param M104_vth0 = 9.749434452362e-01
.param M104_u0 = 9.838420111903e-01
.param M104_voff = 1.011791563021e+00
.param M106_vth0 = 9.808239520308e-01
.param M106_u0 = 1.075908589364e+00
.param M106_voff = 1.110515931975e+00
.param M108_vth0 = 9.754658783744e-01
.param M108_u0 = 9.982879445488e-01
.param M108_voff = 9.630423976615e-01
.param M109_vth0 = 1.024874959486e+00
.param M109_u0 = 9.673721935678e-01
.param M109_voff = 1.054852075183e+00
.param M112_vth0 = 1.002603212479e+00
.param M112_u0 = 1.070222487082e+00
.param M112_voff = 1.058235820876e+00
.param M114_vth0 = 9.736013955564e-01
.param M114_u0 = 1.038023542253e+00
.param M114_voff = 9.755912497815e-01
.param M115_vth0 = 1.024056340222e+00
.param M115_u0 = 1.078893719178e+00
.param M115_voff = 9.848610088715e-01
.param M118_vth0 = 1.042125224660e+00
.param M118_u0 = 1.037820093127e+00
.param M118_voff = 9.656970376657e-01
.param M120_vth0 = 9.726950937472e-01
.param M120_u0 = 9.141907669493e-01
.param M120_voff = 9.417555575137e-01
.param M122_vth0 = 1.045594729439e+00
.param M122_u0 = 1.011608755445e+00
.param M122_voff = 1.101092516870e+00
.param M124_vth0 = 9.433728669039e-01
.param M124_u0 = 1.001559695929e+00
.param M124_voff = 1.010545036664e+00
.param M126_vth0 = 9.715406336562e-01
.param M126_u0 = 9.603818718653e-01
.param M126_voff = 1.012081263700e+00
.param M128_vth0 = 9.740333915505e-01
.param M128_u0 = 9.750303577228e-01
.param M128_voff = 1.015720850866e+00
.param M130_vth0 = 9.322623532921e-01
.param M130_u0 = 1.005690452604e+00
.param M130_voff = 9.036383420509e-01
.param M132_vth0 = 1.052708488415e+00
.param M132_u0 = 9.818875291254e-01
.param M132_voff = 1.017653119230e+00
.param M134_vth0 = 8.207905857815e-01
.param M134_u0 = 1.027997430637e+00
.param M134_voff = 9.661507765337e-01
.param M136_vth0 = 9.435448604315e-01
.param M136_u0 = 1.005826176791e+00
.param M136_voff = 1.049654417740e+00
.param M138_vth0 = 9.582052329920e-01
.param M138_u0 = 9.527396472728e-01
.param M138_voff = 1.094513213907e+00
.param M140_vth0 = 9.591456768877e-01
.param M140_u0 = 1.003125279784e+00
.param M140_voff = 1.074984052692e+00
.param M142_vth0 = 9.894364595432e-01
.param M142_u0 = 9.507052383696e-01
.param M142_voff = 9.767092994907e-01
.param M144_vth0 = 9.202453920637e-01
.param M144_u0 = 1.014450169583e+00
.param M144_voff = 9.754335963764e-01
.param M146_vth0 = 1.043728711276e+00
.param M146_u0 = 9.858819298068e-01
.param M146_voff = 9.801078395925e-01
.param M148_vth0 = 9.775023573784e-01
.param M148_u0 = 9.296929980060e-01
.param M148_voff = 1.000983822082e+00
.param M150_vth0 = 1.057691748445e+00
.param M150_u0 = 9.634381422276e-01
.param M150_voff = 1.011415484109e+00
.param M152_vth0 = 9.163396891930e-01
.param M152_u0 = 1.103208178449e+00
.param M152_voff = 1.051715479542e+00
.param M154_vth0 = 1.054033680081e+00
.param M154_u0 = 1.008429188531e+00
.param M154_voff = 9.811284493103e-01
.param M156_vth0 = 9.452216236248e-01
.param M156_u0 = 9.483599045027e-01
.param M156_voff = 1.001494159225e+00
.param M158_vth0 = 9.266968659480e-01
.param M158_u0 = 9.320866568436e-01
.param M158_voff = 1.031025287811e+00
.param M160_vth0 = 9.911636166065e-01
.param M160_u0 = 9.982939138175e-01
.param M160_voff = 9.777165573762e-01
.param M162_vth0 = 9.829790132730e-01
.param M162_u0 = 9.564473000607e-01
.param M162_voff = 9.724841996210e-01
.param M164_vth0 = 9.554633131599e-01
.param M164_u0 = 1.002047492441e+00
.param M164_voff = 9.570212004365e-01
.param M166_vth0 = 9.914473317559e-01
.param M166_u0 = 9.624958634122e-01
.param M166_voff = 9.980539415261e-01
.param M168_vth0 = 1.026267999362e+00
.param M168_u0 = 1.026365964460e+00
.param M168_voff = 1.047841581771e+00
.param M170_vth0 = 9.639716985486e-01
.param M170_u0 = 9.172249590009e-01
.param M170_voff = 9.595722176328e-01
.param M172_vth0 = 1.008263187171e+00
.param M172_u0 = 1.030359507762e+00
.param M172_voff = 9.400829299267e-01
.param M174_vth0 = 1.021603665223e+00
.param M174_u0 = 1.064508359699e+00
.param M174_voff = 9.790639371813e-01
.param M176_vth0 = 9.274277927312e-01
.param M176_u0 = 9.178563891789e-01
.param M176_voff = 9.063429953111e-01
.param M178_vth0 = 9.636642608045e-01
.param M178_u0 = 1.033250111885e+00
.param M178_voff = 9.845509297009e-01
.param M180_vth0 = 1.021347987514e+00
.param M180_u0 = 9.071959712567e-01
.param M180_voff = 9.437097770442e-01
.param M182_vth0 = 1.109741603722e+00
.param M182_u0 = 8.886535522882e-01
.param M182_voff = 1.015175449035e+00
.param M184_vth0 = 1.040835975940e+00
.param M184_u0 = 9.493453063884e-01
.param M184_voff = 9.494428928217e-01
.param M186_vth0 = 1.031250576498e+00
.param M186_u0 = 9.856641329941e-01
.param M186_voff = 1.058905434320e+00
.param M188_vth0 = 1.006526267020e+00
.param M188_u0 = 9.707234186995e-01
.param M188_voff = 9.980713982757e-01
.param M190_vth0 = 9.433923704601e-01
.param M190_u0 = 9.991440616446e-01
.param M190_voff = 1.005729904248e+00
.param M192_vth0 = 1.025466562643e+00
.param M192_u0 = 1.075560790077e+00
.param M192_voff = 9.683224682677e-01
.param M194_vth0 = 1.009334251868e+00
.param M194_u0 = 1.051502351308e+00
.param M194_voff = 1.059983037209e+00
.param M196_vth0 = 1.069940775171e+00
.param M196_u0 = 9.798350778904e-01
.param M196_voff = 9.334463304276e-01
.param M198_vth0 = 9.807711842454e-01
.param M198_u0 = 1.036198814449e+00
.param M198_voff = 1.117197339680e+00
.param M200_vth0 = 1.009571262784e+00
.param M200_u0 = 9.487669816528e-01
.param M200_voff = 1.035297944349e+00
.param M202_vth0 = 9.940185817126e-01
.param M202_u0 = 1.009280301614e+00
.param M202_voff = 1.011315264282e+00
.param M204_vth0 = 9.965063925494e-01
.param M204_u0 = 1.061482932743e+00
.param M204_voff = 1.036324831015e+00
.param M206_vth0 = 1.033047968902e+00
.param M206_u0 = 9.269340697012e-01
.param M206_voff = 1.005892551132e+00
.param M208_vth0 = 1.006499115299e+00
.param M208_u0 = 8.892559450399e-01
.param M208_voff = 9.913603328124e-01
.param M210_vth0 = 1.029777817172e+00
.param M210_u0 = 9.859953986144e-01
.param M210_voff = 1.008684730627e+00
.param M212_vth0 = 9.835751574132e-01
.param M212_u0 = 9.943574202233e-01
.param M212_voff = 1.067074732640e+00
.param M214_vth0 = 1.050297254249e+00
.param M214_u0 = 9.357335104004e-01
.param M214_voff = 1.048966630612e+00
.param M216_vth0 = 1.043108123701e+00
.param M216_u0 = 1.025076423611e+00
.param M216_voff = 9.906040822143e-01
.param M218_vth0 = 1.024282022243e+00
.param M218_u0 = 1.068222784035e+00
.param M218_voff = 1.046257231628e+00
.param M219_vth0 = 1.041500816370e+00
.param M219_u0 = 1.035284297195e+00
.param M219_voff = 9.675080421842e-01
.param M220_vth0 = 1.015860529912e+00
.param M220_u0 = 9.923700738958e-01
.param M220_voff = 1.030542862942e+00
.param M224_vth0 = 9.830534022233e-01
.param M224_u0 = 1.036036490916e+00
.param M224_voff = 9.026123174230e-01
.param M226_vth0 = 1.003853356508e+00
.param M226_u0 = 9.818829240437e-01
.param M226_voff = 9.780169175184e-01
.param M227_vth0 = 1.023634478994e+00
.param M227_u0 = 1.000104496607e+00
.param M227_voff = 9.801934510210e-01
.param M228_vth0 = 1.049735385663e+00
.param M228_u0 = 9.949971331134e-01
.param M228_voff = 1.012324099032e+00
.param M232_vth0 = 1.035947005199e+00
.param M232_u0 = 9.998954846861e-01
.param M232_voff = 9.924696065453e-01
.param M234_vth0 = 9.748782239304e-01
.param M234_u0 = 9.798340223783e-01
.param M234_voff = 9.597096724310e-01
.param M235_vth0 = 9.279888868942e-01
.param M235_u0 = 9.048402589080e-01
.param M235_voff = 1.024384146017e+00
.param M236_vth0 = 1.049837131790e+00
.param M236_u0 = 1.020120101353e+00
.param M236_voff = 1.020448042284e+00
.param M240_vth0 = 1.039257113862e+00
.param M240_u0 = 9.897782532349e-01
.param M240_voff = 1.048654711453e+00
.param M242_vth0 = 9.025861906517e-01
.param M242_u0 = 1.020946981728e+00
.param M242_voff = 1.022593821737e+00
.param M244_vth0 = 9.397709250425e-01
.param M244_u0 = 1.047838765439e+00
.param M244_voff = 1.054418640707e+00
.param M246_vth0 = 9.589518644866e-01
.param M246_u0 = 9.458162643935e-01
.param M246_voff = 9.471897126043e-01
.param M248_vth0 = 9.072124159381e-01
.param M248_u0 = 9.834116920584e-01
.param M248_voff = 1.060110952706e+00
.param M250_vth0 = 1.063830356392e+00
.param M250_u0 = 9.822101892301e-01
.param M250_voff = 9.340976057457e-01
.param M252_vth0 = 9.918908673500e-01
.param M252_u0 = 9.681212899096e-01
.param M252_voff = 1.082885797190e+00
.param M253_vth0 = 1.115656731388e+00
.param M253_u0 = 9.485392017078e-01
.param M253_voff = 9.771302569202e-01
.param M254_vth0 = 9.843328716361e-01
.param M254_u0 = 1.034003120028e+00
.param M254_voff = 9.633186268316e-01
.param M258_vth0 = 9.337540084478e-01
.param M258_u0 = 1.098469133275e+00
.param M258_voff = 9.900567983636e-01
.param M260_vth0 = 1.006288266823e+00
.param M260_u0 = 9.979301273927e-01
.param M260_voff = 9.639699263979e-01
.param M261_vth0 = 9.602540497831e-01
.param M261_u0 = 1.109470770547e+00
.param M261_voff = 1.038694902913e+00
.param M264_vth0 = 9.513786049309e-01
.param M264_u0 = 1.017037955527e+00
.param M264_voff = 9.724743208802e-01
.param M266_vth0 = 1.047576903181e+00
.param M266_u0 = 1.021635898081e+00
.param M266_voff = 9.110459837855e-01
.param M267_vth0 = 1.113711344193e+00
.param M267_u0 = 9.709328088947e-01
.param M267_voff = 1.038661597900e+00
.param M268_vth0 = 9.794478112607e-01
.param M268_u0 = 9.798945686694e-01
.param M268_voff = 9.075500325849e-01
.param M272_vth0 = 8.879953755948e-01
.param M272_u0 = 1.016699934510e+00
.param M272_voff = 1.039502947160e+00
.param M274_vth0 = 9.904871881279e-01
.param M274_u0 = 9.315177245990e-01
.param M274_voff = 1.000895611984e+00
.param M275_vth0 = 9.855398704753e-01
.param M275_u0 = 9.719797109524e-01
.param M275_voff = 9.473115213481e-01
.param M278_vth0 = 1.045248905150e+00
.param M278_u0 = 9.787509888648e-01
.param M278_voff = 9.993977473640e-01
.param M280_vth0 = 8.864570037216e-01
.param M280_u0 = 9.569104740921e-01
.param M280_voff = 9.955775180838e-01
.param M281_vth0 = 9.068869723547e-01
.param M281_u0 = 1.039081436548e+00
.param M281_voff = 1.013294359771e+00
.param M282_vth0 = 1.024146161108e+00
.param M282_u0 = 9.675263793706e-01
.param M282_voff = 9.653201652604e-01
.param M286_vth0 = 1.047585052221e+00
.param M286_u0 = 9.835900095383e-01
.param M286_voff = 1.087785425135e+00
.param M288_vth0 = 9.148165315012e-01
.param M288_u0 = 1.008907025996e+00
.param M288_voff = 1.103596471590e+00
.param M289_vth0 = 1.103111575347e+00
.param M289_u0 = 1.041518075054e+00
.param M289_voff = 9.593105903571e-01
.param M292_vth0 = 9.926313429018e-01
.param M292_u0 = 1.067000832162e+00
.param M292_voff = 9.929267537069e-01
.param M294_vth0 = 1.049499529232e+00
.param M294_u0 = 1.031820189372e+00
.param M294_voff = 9.882293587849e-01
.param M295_vth0 = 9.436201835058e-01
.param M295_u0 = 1.013402225130e+00
.param M295_voff = 1.005830201260e+00
.param M296_vth0 = 1.046668730791e+00
.param M296_u0 = 1.020642545170e+00
.param M296_voff = 1.036444996728e+00
.param M300_vth0 = 1.007040817302e+00
.param M300_u0 = 1.081786169910e+00
.param M300_voff = 1.021497492807e+00
.param M302_vth0 = 1.055892973866e+00
.param M302_u0 = 1.046264247699e+00
.param M302_voff = 9.403419076532e-01
.param M303_vth0 = 1.050673321741e+00
.param M303_u0 = 1.012087312639e+00
.param M303_voff = 1.018466022824e+00
.param M306_vth0 = 1.045449336346e+00
.param M306_u0 = 9.364333824855e-01
.param M306_voff = 9.984382781905e-01
.param M308_vth0 = 1.016165994859e+00
.param M308_u0 = 1.008319086366e+00
.param M308_voff = 9.749949014886e-01
.param M309_vth0 = 9.489256115706e-01
.param M309_u0 = 9.944427097376e-01
.param M309_voff = 1.031554165381e+00
.param M310_vth0 = 1.036726158800e+00
.param M310_u0 = 1.085497297038e+00
.param M310_voff = 1.005776310498e+00
.param M314_vth0 = 9.932621779646e-01
.param M314_u0 = 1.146686814114e+00
.param M314_voff = 9.949517638217e-01
.param M316_vth0 = 1.020863965008e+00
.param M316_u0 = 1.058254120337e+00
.param M316_voff = 9.341967797966e-01
.param M317_vth0 = 1.001074301824e+00
.param M317_u0 = 1.114836221339e+00
.param M317_voff = 1.026217219392e+00
.param M320_vth0 = 1.034780514524e+00
.param M320_u0 = 1.075775115315e+00
.param M320_voff = 1.014687792256e+00
.param M322_vth0 = 9.348855207822e-01
.param M322_u0 = 1.167642250435e+00
.param M322_voff = 9.917931139721e-01
.param M323_vth0 = 9.662571137450e-01
.param M323_u0 = 1.037837862527e+00
.param M323_voff = 9.748449545737e-01
.param M324_vth0 = 9.925139984986e-01
.param M324_u0 = 9.525025834101e-01
.param M324_voff = 9.945488227690e-01
.param M328_vth0 = 9.778132534245e-01
.param M328_u0 = 9.940951493995e-01
.param M328_voff = 9.568619983039e-01
.param M330_vth0 = 1.073190422421e+00
.param M330_u0 = 9.868531629775e-01
.param M330_voff = 1.054425970548e+00
.param M331_vth0 = 9.990628090626e-01
.param M331_u0 = 9.953979878376e-01
.param M331_voff = 9.336872953116e-01
.param M334_vth0 = 9.647018125124e-01
.param M334_u0 = 9.865163519352e-01
.param M334_voff = 9.664242693618e-01
.param M336_vth0 = 9.254104120301e-01
.param M336_u0 = 9.112363068353e-01
.param M336_voff = 1.017709465926e+00
.param M337_vth0 = 1.004556351299e+00
.param M337_u0 = 9.528738363670e-01
.param M337_voff = 1.089884142369e+00
.param M338_vth0 = 9.891200845065e-01
.param M338_u0 = 9.910487883913e-01
.param M338_voff = 9.534465846183e-01
.param M342_vth0 = 9.673423537781e-01
.param M342_u0 = 9.805142776821e-01
.param M342_voff = 9.548874044555e-01
.param M344_vth0 = 9.891594681321e-01
.param M344_u0 = 1.006246923581e+00
.param M344_voff = 9.389071322996e-01
.param M345_vth0 = 1.004904601985e+00
.param M345_u0 = 1.008838768167e+00
.param M345_voff = 1.019322627082e+00
.param M348_vth0 = 9.460667843511e-01
.param M348_u0 = 9.839782241880e-01
.param M348_voff = 1.053426829654e+00
.param M350_vth0 = 9.496094588088e-01
.param M350_u0 = 9.799165634671e-01
.param M350_voff = 1.009862000351e+00
.param M351_vth0 = 1.024123529449e+00
.param M351_u0 = 1.015883461829e+00
.param M351_voff = 1.041151574047e+00
.param M352_vth0 = 1.056897048873e+00
.param M352_u0 = 9.492207747389e-01
.param M352_voff = 1.046023452231e+00
.param M356_vth0 = 9.933984182467e-01
.param M356_u0 = 1.007686307301e+00
.param M356_voff = 1.075514536546e+00
.param M358_vth0 = 9.733666626928e-01
.param M358_u0 = 9.698271867797e-01
.param M358_voff = 1.037756595817e+00
.param M359_vth0 = 9.762722396321e-01
.param M359_u0 = 1.015080466942e+00
.param M359_voff = 1.043331081484e+00
.param M362_vth0 = 1.096066239264e+00
.param M362_u0 = 9.899047639533e-01
.param M362_voff = 9.737736582445e-01
.param M364_vth0 = 1.002499043184e+00
.param M364_u0 = 1.019811909573e+00
.param M364_voff = 1.011392307332e+00
.param M365_vth0 = 9.786562135560e-01
.param M365_u0 = 1.037055208236e+00
.param M365_voff = 9.633187472648e-01
.param M368_vth0 = 9.184254453075e-01
.param M368_u0 = 9.899096435577e-01
.param M368_voff = 9.655168851018e-01
.param M370_vth0 = 9.223374370098e-01
.param M370_u0 = 9.134759745983e-01
.param M370_voff = 1.035283944243e+00
.param M372_vth0 = 1.028946546413e+00
.param M372_u0 = 1.047932722502e+00
.param M372_voff = 9.250713203658e-01
.param M373_vth0 = 9.930018348016e-01
.param M373_u0 = 9.363142168499e-01
.param M373_voff = 1.019208478281e+00
.param M376_vth0 = 1.038292932625e+00
.param M376_u0 = 1.033189059143e+00
.param M376_voff = 9.456536730660e-01
.param M377_vth0 = 9.685839884034e-01
.param M377_u0 = 1.029059515197e+00
.param M377_voff = 9.719548132874e-01
.param M380_vth0 = 1.043783234096e+00
.param M380_u0 = 9.907645981019e-01
.param M380_voff = 9.823363030708e-01
.param M381_vth0 = 1.020135817918e+00
.param M381_u0 = 9.634123909359e-01
.param M381_voff = 1.060475241084e+00
.param M384_vth0 = 1.170717505432e+00
.param M384_u0 = 1.008515161407e+00
.param M384_voff = 1.011350465731e+00
.param M385_vth0 = 9.993178407816e-01
.param M385_u0 = 1.005073652488e+00
.param M385_voff = 9.599201418249e-01
.param M388_vth0 = 1.090934145978e+00
.param M388_u0 = 1.024409792741e+00
.param M388_voff = 1.027375199070e+00
.param M389_vth0 = 1.007969370898e+00
.param M389_u0 = 1.018521407970e+00
.param M389_voff = 9.116907394022e-01
.param M390_vth0 = 9.818314530393e-01
.param M390_u0 = 1.018674094131e+00
.param M390_voff = 9.214330858501e-01
.param M391_vth0 = 9.987068069367e-01
.param M391_u0 = 1.020794134560e+00
.param M391_voff = 9.931671745074e-01
.param M392_vth0 = 9.884576189521e-01
.param M392_u0 = 9.178174112746e-01
.param M392_voff = 9.514755416525e-01
.param M393_vth0 = 9.143642964241e-01
.param M393_u0 = 9.458933044992e-01
.param M393_voff = 1.071024087813e+00
.param M395_vth0 = 9.415171699090e-01
.param M395_u0 = 1.007125482921e+00
.param M395_voff = 9.813885155294e-01
.param M397_vth0 = 9.104137614962e-01
.param M397_u0 = 1.023945803210e+00
.param M397_voff = 1.050214130584e+00
.param M398_vth0 = 9.742198590519e-01
.param M398_u0 = 9.781406338033e-01
.param M398_voff = 1.064578537804e+00
.param M399_vth0 = 9.049419050272e-01
.param M399_u0 = 1.000259840222e+00
.param M399_voff = 9.782124521759e-01
.param M0_vth0 = 1.031584528703e+00
.param M0_u0 = 1.023707821753e+00
.param M0_voff = 9.709409712298e-01
.param M1_vth0 = 9.867956624103e-01
.param M1_u0 = 9.697096899345e-01
.param M1_voff = 1.032006982376e+00
.param M2_vth0 = 9.413730371046e-01
.param M2_u0 = 9.411375053995e-01
.param M2_voff = 9.989832885361e-01
.param M3_vth0 = 9.582664183845e-01
.param M3_u0 = 1.031534640434e+00
.param M3_voff = 9.952106419344e-01
.param M6_vth0 = 9.988165735661e-01
.param M6_u0 = 1.007082736963e+00
.param M6_voff = 9.549525131502e-01
.param M7_vth0 = 1.073364733706e+00
.param M7_u0 = 9.908331921044e-01
.param M7_voff = 1.071311382091e+00
.param M8_vth0 = 1.035055965071e+00
.param M8_u0 = 1.001427315473e+00
.param M8_voff = 9.793518001484e-01
.param M10_vth0 = 9.597267062392e-01
.param M10_u0 = 9.912174934038e-01
.param M10_voff = 1.004046881247e+00
.param M12_vth0 = 1.029558025367e+00
.param M12_u0 = 1.028623567939e+00
.param M12_voff = 1.030627387327e+00
.param M13_vth0 = 9.816974900843e-01
.param M13_u0 = 9.898227458020e-01
.param M13_voff = 1.018257532645e+00
.param M14_vth0 = 1.049705151664e+00
.param M14_u0 = 9.319367446397e-01
.param M14_voff = 9.806629682520e-01
.param M16_vth0 = 9.544322007464e-01
.param M16_u0 = 8.747880729451e-01
.param M16_voff = 9.555969463232e-01
.param M20_vth0 = 1.041304499517e+00
.param M20_u0 = 1.033213649302e+00
.param M20_voff = 1.074461221686e+00
.param M21_vth0 = 1.007006543543e+00
.param M21_u0 = 1.001681621732e+00
.param M21_voff = 9.556404695159e-01
.param M23_vth0 = 1.009369215891e+00
.param M23_u0 = 1.048384718303e+00
.param M23_voff = 1.028798749491e+00
.param M25_vth0 = 9.773569858756e-01
.param M25_u0 = 1.026636464720e+00
.param M25_voff = 9.879960963243e-01
.param M27_vth0 = 1.103885687221e+00
.param M27_u0 = 9.306215824424e-01
.param M27_voff = 1.046330040371e+00
.param M29_vth0 = 9.871941150931e-01
.param M29_u0 = 9.273939958988e-01
.param M29_voff = 9.281341961092e-01
.param M31_vth0 = 1.021930749908e+00
.param M31_u0 = 9.550709388950e-01
.param M31_voff = 9.875617685105e-01
.param M33_vth0 = 1.012415531859e+00
.param M33_u0 = 1.078536593698e+00
.param M33_voff = 1.026278797525e+00
.param M35_vth0 = 9.863260553461e-01
.param M35_u0 = 1.033570784473e+00
.param M35_voff = 1.017102132978e+00
.param M37_vth0 = 9.691955734579e-01
.param M37_u0 = 1.033321180433e+00
.param M37_voff = 1.003306095254e+00
.param M39_vth0 = 9.246847904681e-01
.param M39_u0 = 9.849266890349e-01
.param M39_voff = 1.030306951550e+00
.param M41_vth0 = 9.883683739941e-01
.param M41_u0 = 9.380413710693e-01
.param M41_voff = 1.043105281292e+00
.param M43_vth0 = 9.287574643982e-01
.param M43_u0 = 9.282969487382e-01
.param M43_voff = 1.007164333762e+00
.param M45_vth0 = 1.012400402771e+00
.param M45_u0 = 9.636065463276e-01
.param M45_voff = 1.031377092746e+00
.param M47_vth0 = 9.866350879778e-01
.param M47_u0 = 9.499840364632e-01
.param M47_voff = 1.023460889173e+00
.param M49_vth0 = 9.584025890312e-01
.param M49_u0 = 1.016659348309e+00
.param M49_voff = 1.065855349654e+00
.param M51_vth0 = 1.049744528863e+00
.param M51_u0 = 1.051837299301e+00
.param M51_voff = 9.691949792389e-01
.param M53_vth0 = 8.956066479216e-01
.param M53_u0 = 1.038956458418e+00
.param M53_voff = 1.018373793150e+00
.param M55_vth0 = 9.634366432778e-01
.param M55_u0 = 9.564262321293e-01
.param M55_voff = 9.476838786592e-01
.param M57_vth0 = 1.035739338676e+00
.param M57_u0 = 9.917815811286e-01
.param M57_voff = 1.019420845808e+00
.param M59_vth0 = 1.062483944461e+00
.param M59_u0 = 1.097515888111e+00
.param M59_voff = 1.029052346832e+00
.param M61_vth0 = 9.534976354829e-01
.param M61_u0 = 9.059736642971e-01
.param M61_voff = 1.037725688211e+00
.param M63_vth0 = 9.872988154295e-01
.param M63_u0 = 9.983251396028e-01
.param M63_voff = 9.038577080839e-01
.param M65_vth0 = 9.986867089078e-01
.param M65_u0 = 1.060685196735e+00
.param M65_voff = 8.767362119988e-01
.param M67_vth0 = 1.008353372458e+00
.param M67_u0 = 1.039446164288e+00
.param M67_voff = 9.731943468195e-01
.param M69_vth0 = 9.822693993583e-01
.param M69_u0 = 1.070158998581e+00
.param M69_voff = 1.025772771649e+00
.param M71_vth0 = 1.026820758977e+00
.param M71_u0 = 1.080557639153e+00
.param M71_voff = 9.744657783213e-01
.param M73_vth0 = 9.703238055723e-01
.param M73_u0 = 9.651211552141e-01
.param M73_voff = 1.013150467156e+00
.param M75_vth0 = 9.561771043631e-01
.param M75_u0 = 1.051802604997e+00
.param M75_voff = 1.032339808632e+00
.param M77_vth0 = 1.023301769929e+00
.param M77_u0 = 1.065204928826e+00
.param M77_voff = 9.297866456689e-01
.param M79_vth0 = 9.811469731210e-01
.param M79_u0 = 9.624128090077e-01
.param M79_voff = 9.816119617492e-01
.param M81_vth0 = 8.730822616239e-01
.param M81_u0 = 9.611921519020e-01
.param M81_voff = 1.142315302621e+00
.param M83_vth0 = 9.928105330953e-01
.param M83_u0 = 1.070519605062e+00
.param M83_voff = 1.018569334316e+00
.param M85_vth0 = 1.021819532394e+00
.param M85_u0 = 1.018089407020e+00
.param M85_voff = 9.452998413535e-01
.param M87_vth0 = 9.994263801917e-01
.param M87_u0 = 1.010158045121e+00
.param M87_voff = 9.733538023652e-01
.param M89_vth0 = 1.032805298227e+00
.param M89_u0 = 1.040605032211e+00
.param M89_voff = 1.081499666800e+00
.param M91_vth0 = 1.039036220005e+00
.param M91_u0 = 9.937705303173e-01
.param M91_voff = 9.865255727025e-01
.param M93_vth0 = 1.075947750086e+00
.param M93_u0 = 9.842303133953e-01
.param M93_voff = 1.021920395994e+00
.param M95_vth0 = 1.018389299941e+00
.param M95_u0 = 1.050821697926e+00
.param M95_voff = 1.029333210899e+00
.param M97_vth0 = 1.013178523543e+00
.param M97_u0 = 1.034646056113e+00
.param M97_voff = 1.063817519016e+00
.param M99_vth0 = 1.026061007103e+00
.param M99_u0 = 9.406166642120e-01
.param M99_voff = 9.963550927562e-01
.param M101_vth0 = 1.004557405346e+00
.param M101_u0 = 9.395359042547e-01
.param M101_voff = 1.043860160376e+00
.param M103_vth0 = 1.114998882662e+00
.param M103_u0 = 8.958254612752e-01
.param M103_voff = 9.751068770218e-01
.param M105_vth0 = 8.993875688081e-01
.param M105_u0 = 1.069987821487e+00
.param M105_voff = 9.457852397088e-01
.param M107_vth0 = 1.119353810531e+00
.param M107_u0 = 9.365598701734e-01
.param M107_voff = 9.372753775509e-01
.param M110_vth0 = 9.566176744761e-01
.param M110_u0 = 1.058162643234e+00
.param M110_voff = 1.001342182053e+00
.param M111_vth0 = 9.275153624987e-01
.param M111_u0 = 9.770788035245e-01
.param M111_voff = 1.139279994566e+00
.param M113_vth0 = 9.196199678514e-01
.param M113_u0 = 1.033558785430e+00
.param M113_voff = 1.135060766640e+00
.param M116_vth0 = 9.913959839427e-01
.param M116_u0 = 8.718650621414e-01
.param M116_voff = 1.089527153129e+00
.param M117_vth0 = 9.711357967220e-01
.param M117_u0 = 9.321187762238e-01
.param M117_voff = 9.710606832191e-01
.param M119_vth0 = 1.049541091284e+00
.param M119_u0 = 9.825443622294e-01
.param M119_voff = 9.725743777285e-01
.param M121_vth0 = 9.298876373129e-01
.param M121_u0 = 1.012531200720e+00
.param M121_voff = 1.013487507397e+00
.param M123_vth0 = 9.993866007985e-01
.param M123_u0 = 9.847975578655e-01
.param M123_voff = 1.002041721791e+00
.param M125_vth0 = 1.085447091945e+00
.param M125_u0 = 1.072748489834e+00
.param M125_voff = 9.564413158051e-01
.param M127_vth0 = 9.173773868065e-01
.param M127_u0 = 1.008297606582e+00
.param M127_voff = 1.000061398010e+00
.param M129_vth0 = 1.081007439581e+00
.param M129_u0 = 9.634243687955e-01
.param M129_voff = 1.037261863651e+00
.param M131_vth0 = 1.114606109836e+00
.param M131_u0 = 1.005778682594e+00
.param M131_voff = 9.649075895879e-01
.param M133_vth0 = 1.104011817827e+00
.param M133_u0 = 1.139163227925e+00
.param M133_voff = 1.083583448196e+00
.param M135_vth0 = 1.022105571729e+00
.param M135_u0 = 1.021750412916e+00
.param M135_voff = 9.774399093718e-01
.param M137_vth0 = 1.083150449069e+00
.param M137_u0 = 9.962685769738e-01
.param M137_voff = 1.067132901962e+00
.param M139_vth0 = 1.098329122066e+00
.param M139_u0 = 9.698507235683e-01
.param M139_voff = 1.038434310622e+00
.param M141_vth0 = 1.056907777476e+00
.param M141_u0 = 1.019085945998e+00
.param M141_voff = 1.085108424712e+00
.param M143_vth0 = 9.854539254235e-01
.param M143_u0 = 8.737327810766e-01
.param M143_voff = 9.603708189851e-01
.param M145_vth0 = 8.888537153760e-01
.param M145_u0 = 9.492548799614e-01
.param M145_voff = 9.980545836043e-01
.param M147_vth0 = 1.002544548227e+00
.param M147_u0 = 9.416453694529e-01
.param M147_voff = 1.015652282460e+00
.param M149_vth0 = 9.963630701784e-01
.param M149_u0 = 9.529478575050e-01
.param M149_voff = 1.040396066336e+00
.param M151_vth0 = 1.047238643122e+00
.param M151_u0 = 1.010285263612e+00
.param M151_voff = 1.015651890609e+00
.param M153_vth0 = 1.004411750359e+00
.param M153_u0 = 1.080046157016e+00
.param M153_voff = 1.010413103118e+00
.param M155_vth0 = 1.034147836317e+00
.param M155_u0 = 1.032013484315e+00
.param M155_voff = 1.037482022091e+00
.param M157_vth0 = 9.327849093558e-01
.param M157_u0 = 9.626906467714e-01
.param M157_voff = 9.127810711701e-01
.param M159_vth0 = 1.029227714139e+00
.param M159_u0 = 9.837647696499e-01
.param M159_voff = 8.810526575599e-01
.param M161_vth0 = 1.027876267676e+00
.param M161_u0 = 9.824696092464e-01
.param M161_voff = 1.011214773543e+00
.param M163_vth0 = 9.476934847336e-01
.param M163_u0 = 9.385966109080e-01
.param M163_voff = 9.879536854999e-01
.param M165_vth0 = 1.004264277347e+00
.param M165_u0 = 1.066974105633e+00
.param M165_voff = 9.787530166716e-01
.param M167_vth0 = 9.762100955228e-01
.param M167_u0 = 1.003725346730e+00
.param M167_voff = 9.804768473595e-01
.param M169_vth0 = 9.841779441547e-01
.param M169_u0 = 1.069583192954e+00
.param M169_voff = 1.002786738995e+00
.param M171_vth0 = 1.013794620522e+00
.param M171_u0 = 9.252903179115e-01
.param M171_voff = 1.088148549337e+00
.param M173_vth0 = 1.030731038002e+00
.param M173_u0 = 9.966776493784e-01
.param M173_voff = 9.265180515234e-01
.param M175_vth0 = 9.624864362918e-01
.param M175_u0 = 1.050508908767e+00
.param M175_voff = 1.074929825616e+00
.param M177_vth0 = 9.309001280367e-01
.param M177_u0 = 1.100237150412e+00
.param M177_voff = 1.067347371129e+00
.param M179_vth0 = 1.050374998772e+00
.param M179_u0 = 1.044476781873e+00
.param M179_voff = 9.787944121517e-01
.param M181_vth0 = 1.019449090071e+00
.param M181_u0 = 1.052697682082e+00
.param M181_voff = 9.463754660374e-01
.param M183_vth0 = 9.899064452520e-01
.param M183_u0 = 1.038532483236e+00
.param M183_voff = 9.997869190928e-01
.param M185_vth0 = 1.006684751792e+00
.param M185_u0 = 9.877565155321e-01
.param M185_voff = 1.028998073438e+00
.param M187_vth0 = 1.083614197051e+00
.param M187_u0 = 1.020319314582e+00
.param M187_voff = 9.858898707439e-01
.param M189_vth0 = 9.245125028028e-01
.param M189_u0 = 9.976130978632e-01
.param M189_voff = 1.015607721124e+00
.param M191_vth0 = 9.931254700705e-01
.param M191_u0 = 1.042452397260e+00
.param M191_voff = 1.030996994956e+00
.param M193_vth0 = 1.032601943569e+00
.param M193_u0 = 1.035385686570e+00
.param M193_voff = 1.009490546977e+00
.param M195_vth0 = 9.933805100717e-01
.param M195_u0 = 1.044724074336e+00
.param M195_voff = 1.036453476282e+00
.param M197_vth0 = 1.043859305950e+00
.param M197_u0 = 9.964364805879e-01
.param M197_voff = 1.017349443530e+00
.param M199_vth0 = 9.409516453710e-01
.param M199_u0 = 9.938981529710e-01
.param M199_voff = 1.058060785010e+00
.param M201_vth0 = 1.084741358096e+00
.param M201_u0 = 9.628221230824e-01
.param M201_voff = 1.018610818489e+00
.param M203_vth0 = 1.056417651114e+00
.param M203_u0 = 1.057854802844e+00
.param M203_voff = 9.967933679642e-01
.param M205_vth0 = 9.960236052160e-01
.param M205_u0 = 1.002934132534e+00
.param M205_voff = 9.877936544518e-01
.param M207_vth0 = 9.648555854927e-01
.param M207_u0 = 9.451259058680e-01
.param M207_voff = 9.984373669460e-01
.param M209_vth0 = 9.583244904699e-01
.param M209_u0 = 1.048731605820e+00
.param M209_voff = 9.648873454436e-01
.param M211_vth0 = 1.048315479529e+00
.param M211_u0 = 1.038590317936e+00
.param M211_voff = 9.979866961654e-01
.param M213_vth0 = 1.020191726720e+00
.param M213_u0 = 9.608495221553e-01
.param M213_voff = 9.410411574775e-01
.param M215_vth0 = 1.140688214263e+00
.param M215_u0 = 9.865582244638e-01
.param M215_voff = 1.013339869039e+00
.param M217_vth0 = 9.471379361159e-01
.param M217_u0 = 9.369511932017e-01
.param M217_voff = 9.700194511453e-01
.param M221_vth0 = 1.017653505258e+00
.param M221_u0 = 1.061892211847e+00
.param M221_voff = 9.866458674429e-01
.param M222_vth0 = 1.026392175895e+00
.param M222_u0 = 1.098121133736e+00
.param M222_voff = 1.049816209002e+00
.param M223_vth0 = 9.933035906969e-01
.param M223_u0 = 1.107215669088e+00
.param M223_voff = 1.028540544314e+00
.param M225_vth0 = 1.003399903485e+00
.param M225_u0 = 9.952246302761e-01
.param M225_voff = 9.728559701681e-01
.param M229_vth0 = 1.029684659447e+00
.param M229_u0 = 9.985240558237e-01
.param M229_voff = 9.904351490075e-01
.param M230_vth0 = 9.860090769061e-01
.param M230_u0 = 9.484619053742e-01
.param M230_voff = 1.021186913179e+00
.param M231_vth0 = 9.522764439980e-01
.param M231_u0 = 1.014051632273e+00
.param M231_voff = 1.084704763592e+00
.param M233_vth0 = 9.189183252737e-01
.param M233_u0 = 1.049475386156e+00
.param M233_voff = 9.784519634078e-01
.param M237_vth0 = 9.743458074012e-01
.param M237_u0 = 1.005643242914e+00
.param M237_voff = 1.043482774270e+00
.param M238_vth0 = 9.678931229315e-01
.param M238_u0 = 1.039070808570e+00
.param M238_voff = 9.840970990912e-01
.param M239_vth0 = 9.832953957804e-01
.param M239_u0 = 1.023874440251e+00
.param M239_voff = 9.120590066055e-01
.param M241_vth0 = 1.034634180665e+00
.param M241_u0 = 9.816464842019e-01
.param M241_voff = 1.055039077731e+00
.param M243_vth0 = 9.669909744140e-01
.param M243_u0 = 1.063543785486e+00
.param M243_voff = 9.668920271053e-01
.param M245_vth0 = 1.011021673457e+00
.param M245_u0 = 9.206880657914e-01
.param M245_voff = 9.804756246918e-01
.param M247_vth0 = 1.058100139714e+00
.param M247_u0 = 9.059229354623e-01
.param M247_voff = 1.085986110908e+00
.param M249_vth0 = 9.478588760874e-01
.param M249_u0 = 1.070058482957e+00
.param M249_voff = 1.095168537092e+00
.param M251_vth0 = 1.021048725073e+00
.param M251_u0 = 1.054574450900e+00
.param M251_voff = 1.051924391829e+00
.param M255_vth0 = 1.099241158042e+00
.param M255_u0 = 9.714886785580e-01
.param M255_voff = 1.065131105652e+00
.param M256_vth0 = 1.025533403237e+00
.param M256_u0 = 9.669452107672e-01
.param M256_voff = 9.499045600059e-01
.param M257_vth0 = 1.023606929267e+00
.param M257_u0 = 1.020963477198e+00
.param M257_voff = 9.696530787127e-01
.param M259_vth0 = 1.005273983293e+00
.param M259_u0 = 1.014219400599e+00
.param M259_voff = 1.027052806533e+00
.param M262_vth0 = 1.078590848179e+00
.param M262_u0 = 9.563960183464e-01
.param M262_voff = 9.433534887196e-01
.param M263_vth0 = 1.013804234943e+00
.param M263_u0 = 9.813995975196e-01
.param M263_voff = 1.019260354526e+00
.param M265_vth0 = 1.054778551518e+00
.param M265_u0 = 9.807146290043e-01
.param M265_voff = 1.019526101188e+00
.param M269_vth0 = 1.044226442587e+00
.param M269_u0 = 9.616658993671e-01
.param M269_voff = 9.832035324519e-01
.param M270_vth0 = 1.009928283786e+00
.param M270_u0 = 1.036350670095e+00
.param M270_voff = 9.627936000670e-01
.param M271_vth0 = 1.048726445308e+00
.param M271_u0 = 1.077155769160e+00
.param M271_voff = 9.989337314059e-01
.param M273_vth0 = 1.007714272450e+00
.param M273_u0 = 9.569702991015e-01
.param M273_voff = 1.060074610038e+00
.param M276_vth0 = 9.756306269520e-01
.param M276_u0 = 1.002614704560e+00
.param M276_voff = 1.013774157381e+00
.param M277_vth0 = 9.769282283471e-01
.param M277_u0 = 9.370413070713e-01
.param M277_voff = 1.019358006919e+00
.param M279_vth0 = 1.055584414028e+00
.param M279_u0 = 9.920231569009e-01
.param M279_voff = 1.030691152361e+00
.param M283_vth0 = 9.504668050223e-01
.param M283_u0 = 1.046796503720e+00
.param M283_voff = 9.471487906981e-01
.param M284_vth0 = 1.059489579007e+00
.param M284_u0 = 9.561442585463e-01
.param M284_voff = 9.861141848821e-01
.param M285_vth0 = 9.124526145211e-01
.param M285_u0 = 9.430036270891e-01
.param M285_voff = 1.037630685170e+00
.param M287_vth0 = 9.054467406524e-01
.param M287_u0 = 1.025064130612e+00
.param M287_voff = 1.087256265525e+00
.param M290_vth0 = 1.012346151054e+00
.param M290_u0 = 9.981346038726e-01
.param M290_voff = 1.034745276671e+00
.param M291_vth0 = 1.056608626676e+00
.param M291_u0 = 9.421699936983e-01
.param M291_voff = 1.008950348320e+00
.param M293_vth0 = 9.998780359515e-01
.param M293_u0 = 1.003666046567e+00
.param M293_voff = 1.050515503735e+00
.param M297_vth0 = 1.051207032613e+00
.param M297_u0 = 1.027176268729e+00
.param M297_voff = 1.029480195421e+00
.param M298_vth0 = 9.615178272890e-01
.param M298_u0 = 1.006351578912e+00
.param M298_voff = 1.022507851399e+00
.param M299_vth0 = 9.728043326764e-01
.param M299_u0 = 1.153753120782e+00
.param M299_voff = 1.024306191724e+00
.param M301_vth0 = 1.003603027261e+00
.param M301_u0 = 1.024863273220e+00
.param M301_voff = 9.260145147868e-01
.param M304_vth0 = 1.021438378616e+00
.param M304_u0 = 1.054480927719e+00
.param M304_voff = 1.054406562200e+00
.param M305_vth0 = 9.741108654604e-01
.param M305_u0 = 9.306672492636e-01
.param M305_voff = 1.004637973918e+00
.param M307_vth0 = 1.056007036228e+00
.param M307_u0 = 9.960105911757e-01
.param M307_voff = 9.803529872476e-01
.param M311_vth0 = 9.840363447282e-01
.param M311_u0 = 1.004017170892e+00
.param M311_voff = 1.052244388131e+00
.param M312_vth0 = 1.049527635026e+00
.param M312_u0 = 9.120562542502e-01
.param M312_voff = 9.914594848562e-01
.param M313_vth0 = 9.957428158296e-01
.param M313_u0 = 1.033931944485e+00
.param M313_voff = 1.010345535955e+00
.param M315_vth0 = 9.789436358513e-01
.param M315_u0 = 1.087989890068e+00
.param M315_voff = 8.987978640982e-01
.param M318_vth0 = 9.207129913060e-01
.param M318_u0 = 9.725436482772e-01
.param M318_voff = 9.586106529196e-01
.param M319_vth0 = 9.772084963920e-01
.param M319_u0 = 1.036714991227e+00
.param M319_voff = 9.822501468094e-01
.param M321_vth0 = 9.146950106124e-01
.param M321_u0 = 1.061166835572e+00
.param M321_voff = 1.011879228098e+00
.param M325_vth0 = 9.762882879666e-01
.param M325_u0 = 9.784716078455e-01
.param M325_voff = 1.025640778650e+00
.param M326_vth0 = 9.897402553912e-01
.param M326_u0 = 9.877144235088e-01
.param M326_voff = 9.831794490356e-01
.param M327_vth0 = 9.999991907748e-01
.param M327_u0 = 1.053642355689e+00
.param M327_voff = 9.230053212527e-01
.param M329_vth0 = 1.025550062927e+00
.param M329_u0 = 1.017938330222e+00
.param M329_voff = 1.107526119269e+00
.param M332_vth0 = 1.017259030267e+00
.param M332_u0 = 9.100286939063e-01
.param M332_voff = 1.067654076288e+00
.param M333_vth0 = 1.007580845994e+00
.param M333_u0 = 9.690544958404e-01
.param M333_voff = 9.970660528036e-01
.param M335_vth0 = 9.891511961536e-01
.param M335_u0 = 1.122992234457e+00
.param M335_voff = 1.013802830892e+00
.param M339_vth0 = 1.017651698057e+00
.param M339_u0 = 1.027383779503e+00
.param M339_voff = 1.064839298948e+00
.param M340_vth0 = 9.655376602405e-01
.param M340_u0 = 9.810072578075e-01
.param M340_voff = 9.196131000357e-01
.param M341_vth0 = 9.740794688297e-01
.param M341_u0 = 9.313771452737e-01
.param M341_voff = 1.014874459315e+00
.param M343_vth0 = 9.870772914000e-01
.param M343_u0 = 9.847886125377e-01
.param M343_voff = 9.901433076269e-01
.param M346_vth0 = 1.031871745511e+00
.param M346_u0 = 9.881909563488e-01
.param M346_voff = 1.100609976462e+00
.param M347_vth0 = 9.773798135722e-01
.param M347_u0 = 1.119745640398e+00
.param M347_voff = 8.981690162948e-01
.param M349_vth0 = 1.051232036529e+00
.param M349_u0 = 9.913424717129e-01
.param M349_voff = 9.776196792274e-01
.param M353_vth0 = 1.017350335647e+00
.param M353_u0 = 1.018733277126e+00
.param M353_voff = 1.041680120302e+00
.param M354_vth0 = 1.014479803501e+00
.param M354_u0 = 9.465371441223e-01
.param M354_voff = 1.001444228225e+00
.param M355_vth0 = 1.115948693309e+00
.param M355_u0 = 1.001400428322e+00
.param M355_voff = 9.762386199162e-01
.param M357_vth0 = 9.578809891301e-01
.param M357_u0 = 9.537414365115e-01
.param M357_voff = 8.952522098374e-01
.param M360_vth0 = 1.006439160119e+00
.param M360_u0 = 1.011583144917e+00
.param M360_voff = 1.026667590580e+00
.param M361_vth0 = 9.398721909079e-01
.param M361_u0 = 9.160459284395e-01
.param M361_voff = 9.953987950781e-01
.param M363_vth0 = 1.017450819552e+00
.param M363_u0 = 1.037847960664e+00
.param M363_voff = 9.138271787546e-01
.param M366_vth0 = 1.004957428209e+00
.param M366_u0 = 9.747190143121e-01
.param M366_voff = 9.880641685290e-01
.param M367_vth0 = 1.033022652633e+00
.param M367_u0 = 1.001672172792e+00
.param M367_voff = 8.810819245915e-01
.param M369_vth0 = 9.891315299727e-01
.param M369_u0 = 1.036763866177e+00
.param M369_voff = 9.749244000266e-01
.param M371_vth0 = 1.039499987329e+00
.param M371_u0 = 1.104700253828e+00
.param M371_voff = 1.029861295848e+00
.param M374_vth0 = 1.031362081276e+00
.param M374_u0 = 9.997331819792e-01
.param M374_voff = 1.023865312198e+00
.param M375_vth0 = 9.937060524518e-01
.param M375_u0 = 1.063898625815e+00
.param M375_voff = 9.698992881916e-01
.param M378_vth0 = 9.643970030536e-01
.param M378_u0 = 1.013606447445e+00
.param M378_voff = 1.000273852986e+00
.param M379_vth0 = 1.049374214201e+00
.param M379_u0 = 9.950575562104e-01
.param M379_voff = 9.295350172765e-01
.param M382_vth0 = 9.483795465441e-01
.param M382_u0 = 9.666006124794e-01
.param M382_voff = 9.112661128154e-01
.param M383_vth0 = 1.035627709672e+00
.param M383_u0 = 1.078352762801e+00
.param M383_voff = 1.013754650942e+00
.param M386_vth0 = 1.015525840643e+00
.param M386_u0 = 1.049721674871e+00
.param M386_voff = 9.408487258478e-01
.param M387_vth0 = 1.066133354734e+00
.param M387_u0 = 9.954387075017e-01
.param M387_voff = 8.882551786011e-01
.param M394_vth0 = 1.049180077053e+00
.param M394_u0 = 9.074269370717e-01
.param M394_voff = 9.531328258116e-01
.param M396_vth0 = 9.545174151610e-01
.param M396_u0 = 1.003398830113e+00
.param M396_voff = 1.011121377242e+00
.param M400_vth0 = 9.169731696018e-01
.param M400_u0 = 9.697951133672e-01
.param M400_voff = 9.087538239372e-01
