* Automatically generated baseline models
.model m_local_4 pmos level=8 version=3.3.0 vth0={M4_vth0} u0={M4_u0} voff={M4_voff}
.model m_local_5 pmos level=8 version=3.3.0 vth0={M5_vth0} u0={M5_u0} voff={M5_voff}
.model m_local_9 pmos level=8 version=3.3.0 vth0={M9_vth0} u0={M9_u0} voff={M9_voff}
.model m_local_11 pmos level=8 version=3.3.0 vth0={M11_vth0} u0={M11_u0} voff={M11_voff}
.model m_local_15 pmos level=8 version=3.3.0 vth0={M15_vth0} u0={M15_u0} voff={M15_voff}
.model m_local_17 pmos level=8 version=3.3.0 vth0={M17_vth0} u0={M17_u0} voff={M17_voff}
.model m_local_18 pmos level=8 version=3.3.0 vth0={M18_vth0} u0={M18_u0} voff={M18_voff}
.model m_local_19 pmos level=8 version=3.3.0 vth0={M19_vth0} u0={M19_u0} voff={M19_voff}
.model m_local_22 pmos level=8 version=3.3.0 vth0={M22_vth0} u0={M22_u0} voff={M22_voff}
.model m_local_24 pmos level=8 version=3.3.0 vth0={M24_vth0} u0={M24_u0} voff={M24_voff}
.model m_local_26 pmos level=8 version=3.3.0 vth0={M26_vth0} u0={M26_u0} voff={M26_voff}
.model m_local_28 pmos level=8 version=3.3.0 vth0={M28_vth0} u0={M28_u0} voff={M28_voff}
.model m_local_30 pmos level=8 version=3.3.0 vth0={M30_vth0} u0={M30_u0} voff={M30_voff}
.model m_local_32 pmos level=8 version=3.3.0 vth0={M32_vth0} u0={M32_u0} voff={M32_voff}
.model m_local_34 pmos level=8 version=3.3.0 vth0={M34_vth0} u0={M34_u0} voff={M34_voff}
.model m_local_36 pmos level=8 version=3.3.0 vth0={M36_vth0} u0={M36_u0} voff={M36_voff}
.model m_local_38 pmos level=8 version=3.3.0 vth0={M38_vth0} u0={M38_u0} voff={M38_voff}
.model m_local_40 pmos level=8 version=3.3.0 vth0={M40_vth0} u0={M40_u0} voff={M40_voff}
.model m_local_42 pmos level=8 version=3.3.0 vth0={M42_vth0} u0={M42_u0} voff={M42_voff}
.model m_local_44 pmos level=8 version=3.3.0 vth0={M44_vth0} u0={M44_u0} voff={M44_voff}
.model m_local_46 pmos level=8 version=3.3.0 vth0={M46_vth0} u0={M46_u0} voff={M46_voff}
.model m_local_48 pmos level=8 version=3.3.0 vth0={M48_vth0} u0={M48_u0} voff={M48_voff}
.model m_local_50 pmos level=8 version=3.3.0 vth0={M50_vth0} u0={M50_u0} voff={M50_voff}
.model m_local_52 pmos level=8 version=3.3.0 vth0={M52_vth0} u0={M52_u0} voff={M52_voff}
.model m_local_54 pmos level=8 version=3.3.0 vth0={M54_vth0} u0={M54_u0} voff={M54_voff}
.model m_local_56 pmos level=8 version=3.3.0 vth0={M56_vth0} u0={M56_u0} voff={M56_voff}
.model m_local_58 pmos level=8 version=3.3.0 vth0={M58_vth0} u0={M58_u0} voff={M58_voff}
.model m_local_60 pmos level=8 version=3.3.0 vth0={M60_vth0} u0={M60_u0} voff={M60_voff}
.model m_local_62 pmos level=8 version=3.3.0 vth0={M62_vth0} u0={M62_u0} voff={M62_voff}
.model m_local_64 pmos level=8 version=3.3.0 vth0={M64_vth0} u0={M64_u0} voff={M64_voff}
.model m_local_66 pmos level=8 version=3.3.0 vth0={M66_vth0} u0={M66_u0} voff={M66_voff}
.model m_local_68 pmos level=8 version=3.3.0 vth0={M68_vth0} u0={M68_u0} voff={M68_voff}
.model m_local_70 pmos level=8 version=3.3.0 vth0={M70_vth0} u0={M70_u0} voff={M70_voff}
.model m_local_72 pmos level=8 version=3.3.0 vth0={M72_vth0} u0={M72_u0} voff={M72_voff}
.model m_local_74 pmos level=8 version=3.3.0 vth0={M74_vth0} u0={M74_u0} voff={M74_voff}
.model m_local_76 pmos level=8 version=3.3.0 vth0={M76_vth0} u0={M76_u0} voff={M76_voff}
.model m_local_78 pmos level=8 version=3.3.0 vth0={M78_vth0} u0={M78_u0} voff={M78_voff}
.model m_local_80 pmos level=8 version=3.3.0 vth0={M80_vth0} u0={M80_u0} voff={M80_voff}
.model m_local_82 pmos level=8 version=3.3.0 vth0={M82_vth0} u0={M82_u0} voff={M82_voff}
.model m_local_84 pmos level=8 version=3.3.0 vth0={M84_vth0} u0={M84_u0} voff={M84_voff}
.model m_local_86 pmos level=8 version=3.3.0 vth0={M86_vth0} u0={M86_u0} voff={M86_voff}
.model m_local_88 pmos level=8 version=3.3.0 vth0={M88_vth0} u0={M88_u0} voff={M88_voff}
.model m_local_90 pmos level=8 version=3.3.0 vth0={M90_vth0} u0={M90_u0} voff={M90_voff}
.model m_local_92 pmos level=8 version=3.3.0 vth0={M92_vth0} u0={M92_u0} voff={M92_voff}
.model m_local_94 pmos level=8 version=3.3.0 vth0={M94_vth0} u0={M94_u0} voff={M94_voff}
.model m_local_96 pmos level=8 version=3.3.0 vth0={M96_vth0} u0={M96_u0} voff={M96_voff}
.model m_local_98 pmos level=8 version=3.3.0 vth0={M98_vth0} u0={M98_u0} voff={M98_voff}
.model m_local_100 pmos level=8 version=3.3.0 vth0={M100_vth0} u0={M100_u0} voff={M100_voff}
.model m_local_102 pmos level=8 version=3.3.0 vth0={M102_vth0} u0={M102_u0} voff={M102_voff}
.model m_local_104 pmos level=8 version=3.3.0 vth0={M104_vth0} u0={M104_u0} voff={M104_voff}
.model m_local_106 pmos level=8 version=3.3.0 vth0={M106_vth0} u0={M106_u0} voff={M106_voff}
.model m_local_108 pmos level=8 version=3.3.0 vth0={M108_vth0} u0={M108_u0} voff={M108_voff}
.model m_local_109 pmos level=8 version=3.3.0 vth0={M109_vth0} u0={M109_u0} voff={M109_voff}
.model m_local_112 pmos level=8 version=3.3.0 vth0={M112_vth0} u0={M112_u0} voff={M112_voff}
.model m_local_114 pmos level=8 version=3.3.0 vth0={M114_vth0} u0={M114_u0} voff={M114_voff}
.model m_local_115 pmos level=8 version=3.3.0 vth0={M115_vth0} u0={M115_u0} voff={M115_voff}
.model m_local_118 pmos level=8 version=3.3.0 vth0={M118_vth0} u0={M118_u0} voff={M118_voff}
.model m_local_120 pmos level=8 version=3.3.0 vth0={M120_vth0} u0={M120_u0} voff={M120_voff}
.model m_local_122 pmos level=8 version=3.3.0 vth0={M122_vth0} u0={M122_u0} voff={M122_voff}
.model m_local_124 pmos level=8 version=3.3.0 vth0={M124_vth0} u0={M124_u0} voff={M124_voff}
.model m_local_126 pmos level=8 version=3.3.0 vth0={M126_vth0} u0={M126_u0} voff={M126_voff}
.model m_local_128 pmos level=8 version=3.3.0 vth0={M128_vth0} u0={M128_u0} voff={M128_voff}
.model m_local_130 pmos level=8 version=3.3.0 vth0={M130_vth0} u0={M130_u0} voff={M130_voff}
.model m_local_132 pmos level=8 version=3.3.0 vth0={M132_vth0} u0={M132_u0} voff={M132_voff}
.model m_local_134 pmos level=8 version=3.3.0 vth0={M134_vth0} u0={M134_u0} voff={M134_voff}
.model m_local_136 pmos level=8 version=3.3.0 vth0={M136_vth0} u0={M136_u0} voff={M136_voff}
.model m_local_138 pmos level=8 version=3.3.0 vth0={M138_vth0} u0={M138_u0} voff={M138_voff}
.model m_local_140 pmos level=8 version=3.3.0 vth0={M140_vth0} u0={M140_u0} voff={M140_voff}
.model m_local_142 pmos level=8 version=3.3.0 vth0={M142_vth0} u0={M142_u0} voff={M142_voff}
.model m_local_144 pmos level=8 version=3.3.0 vth0={M144_vth0} u0={M144_u0} voff={M144_voff}
.model m_local_146 pmos level=8 version=3.3.0 vth0={M146_vth0} u0={M146_u0} voff={M146_voff}
.model m_local_148 pmos level=8 version=3.3.0 vth0={M148_vth0} u0={M148_u0} voff={M148_voff}
.model m_local_150 pmos level=8 version=3.3.0 vth0={M150_vth0} u0={M150_u0} voff={M150_voff}
.model m_local_152 pmos level=8 version=3.3.0 vth0={M152_vth0} u0={M152_u0} voff={M152_voff}
.model m_local_154 pmos level=8 version=3.3.0 vth0={M154_vth0} u0={M154_u0} voff={M154_voff}
.model m_local_156 pmos level=8 version=3.3.0 vth0={M156_vth0} u0={M156_u0} voff={M156_voff}
.model m_local_158 pmos level=8 version=3.3.0 vth0={M158_vth0} u0={M158_u0} voff={M158_voff}
.model m_local_160 pmos level=8 version=3.3.0 vth0={M160_vth0} u0={M160_u0} voff={M160_voff}
.model m_local_162 pmos level=8 version=3.3.0 vth0={M162_vth0} u0={M162_u0} voff={M162_voff}
.model m_local_164 pmos level=8 version=3.3.0 vth0={M164_vth0} u0={M164_u0} voff={M164_voff}
.model m_local_166 pmos level=8 version=3.3.0 vth0={M166_vth0} u0={M166_u0} voff={M166_voff}
.model m_local_168 pmos level=8 version=3.3.0 vth0={M168_vth0} u0={M168_u0} voff={M168_voff}
.model m_local_170 pmos level=8 version=3.3.0 vth0={M170_vth0} u0={M170_u0} voff={M170_voff}
.model m_local_172 pmos level=8 version=3.3.0 vth0={M172_vth0} u0={M172_u0} voff={M172_voff}
.model m_local_174 pmos level=8 version=3.3.0 vth0={M174_vth0} u0={M174_u0} voff={M174_voff}
.model m_local_176 pmos level=8 version=3.3.0 vth0={M176_vth0} u0={M176_u0} voff={M176_voff}
.model m_local_178 pmos level=8 version=3.3.0 vth0={M178_vth0} u0={M178_u0} voff={M178_voff}
.model m_local_180 pmos level=8 version=3.3.0 vth0={M180_vth0} u0={M180_u0} voff={M180_voff}
.model m_local_182 pmos level=8 version=3.3.0 vth0={M182_vth0} u0={M182_u0} voff={M182_voff}
.model m_local_184 pmos level=8 version=3.3.0 vth0={M184_vth0} u0={M184_u0} voff={M184_voff}
.model m_local_186 pmos level=8 version=3.3.0 vth0={M186_vth0} u0={M186_u0} voff={M186_voff}
.model m_local_188 pmos level=8 version=3.3.0 vth0={M188_vth0} u0={M188_u0} voff={M188_voff}
.model m_local_190 pmos level=8 version=3.3.0 vth0={M190_vth0} u0={M190_u0} voff={M190_voff}
.model m_local_192 pmos level=8 version=3.3.0 vth0={M192_vth0} u0={M192_u0} voff={M192_voff}
.model m_local_194 pmos level=8 version=3.3.0 vth0={M194_vth0} u0={M194_u0} voff={M194_voff}
.model m_local_196 pmos level=8 version=3.3.0 vth0={M196_vth0} u0={M196_u0} voff={M196_voff}
.model m_local_198 pmos level=8 version=3.3.0 vth0={M198_vth0} u0={M198_u0} voff={M198_voff}
.model m_local_200 pmos level=8 version=3.3.0 vth0={M200_vth0} u0={M200_u0} voff={M200_voff}
.model m_local_202 pmos level=8 version=3.3.0 vth0={M202_vth0} u0={M202_u0} voff={M202_voff}
.model m_local_204 pmos level=8 version=3.3.0 vth0={M204_vth0} u0={M204_u0} voff={M204_voff}
.model m_local_206 pmos level=8 version=3.3.0 vth0={M206_vth0} u0={M206_u0} voff={M206_voff}
.model m_local_208 pmos level=8 version=3.3.0 vth0={M208_vth0} u0={M208_u0} voff={M208_voff}
.model m_local_210 pmos level=8 version=3.3.0 vth0={M210_vth0} u0={M210_u0} voff={M210_voff}
.model m_local_212 pmos level=8 version=3.3.0 vth0={M212_vth0} u0={M212_u0} voff={M212_voff}
.model m_local_214 pmos level=8 version=3.3.0 vth0={M214_vth0} u0={M214_u0} voff={M214_voff}
.model m_local_216 pmos level=8 version=3.3.0 vth0={M216_vth0} u0={M216_u0} voff={M216_voff}
.model m_local_218 pmos level=8 version=3.3.0 vth0={M218_vth0} u0={M218_u0} voff={M218_voff}
.model m_local_219 pmos level=8 version=3.3.0 vth0={M219_vth0} u0={M219_u0} voff={M219_voff}
.model m_local_220 pmos level=8 version=3.3.0 vth0={M220_vth0} u0={M220_u0} voff={M220_voff}
.model m_local_224 pmos level=8 version=3.3.0 vth0={M224_vth0} u0={M224_u0} voff={M224_voff}
.model m_local_226 pmos level=8 version=3.3.0 vth0={M226_vth0} u0={M226_u0} voff={M226_voff}
.model m_local_227 pmos level=8 version=3.3.0 vth0={M227_vth0} u0={M227_u0} voff={M227_voff}
.model m_local_228 pmos level=8 version=3.3.0 vth0={M228_vth0} u0={M228_u0} voff={M228_voff}
.model m_local_232 pmos level=8 version=3.3.0 vth0={M232_vth0} u0={M232_u0} voff={M232_voff}
.model m_local_234 pmos level=8 version=3.3.0 vth0={M234_vth0} u0={M234_u0} voff={M234_voff}
.model m_local_235 pmos level=8 version=3.3.0 vth0={M235_vth0} u0={M235_u0} voff={M235_voff}
.model m_local_236 pmos level=8 version=3.3.0 vth0={M236_vth0} u0={M236_u0} voff={M236_voff}
.model m_local_240 pmos level=8 version=3.3.0 vth0={M240_vth0} u0={M240_u0} voff={M240_voff}
.model m_local_242 pmos level=8 version=3.3.0 vth0={M242_vth0} u0={M242_u0} voff={M242_voff}
.model m_local_244 pmos level=8 version=3.3.0 vth0={M244_vth0} u0={M244_u0} voff={M244_voff}
.model m_local_246 pmos level=8 version=3.3.0 vth0={M246_vth0} u0={M246_u0} voff={M246_voff}
.model m_local_248 pmos level=8 version=3.3.0 vth0={M248_vth0} u0={M248_u0} voff={M248_voff}
.model m_local_250 pmos level=8 version=3.3.0 vth0={M250_vth0} u0={M250_u0} voff={M250_voff}
.model m_local_252 pmos level=8 version=3.3.0 vth0={M252_vth0} u0={M252_u0} voff={M252_voff}
.model m_local_253 pmos level=8 version=3.3.0 vth0={M253_vth0} u0={M253_u0} voff={M253_voff}
.model m_local_254 pmos level=8 version=3.3.0 vth0={M254_vth0} u0={M254_u0} voff={M254_voff}
.model m_local_258 pmos level=8 version=3.3.0 vth0={M258_vth0} u0={M258_u0} voff={M258_voff}
.model m_local_260 pmos level=8 version=3.3.0 vth0={M260_vth0} u0={M260_u0} voff={M260_voff}
.model m_local_261 pmos level=8 version=3.3.0 vth0={M261_vth0} u0={M261_u0} voff={M261_voff}
.model m_local_264 pmos level=8 version=3.3.0 vth0={M264_vth0} u0={M264_u0} voff={M264_voff}
.model m_local_266 pmos level=8 version=3.3.0 vth0={M266_vth0} u0={M266_u0} voff={M266_voff}
.model m_local_267 pmos level=8 version=3.3.0 vth0={M267_vth0} u0={M267_u0} voff={M267_voff}
.model m_local_268 pmos level=8 version=3.3.0 vth0={M268_vth0} u0={M268_u0} voff={M268_voff}
.model m_local_272 pmos level=8 version=3.3.0 vth0={M272_vth0} u0={M272_u0} voff={M272_voff}
.model m_local_274 pmos level=8 version=3.3.0 vth0={M274_vth0} u0={M274_u0} voff={M274_voff}
.model m_local_275 pmos level=8 version=3.3.0 vth0={M275_vth0} u0={M275_u0} voff={M275_voff}
.model m_local_278 pmos level=8 version=3.3.0 vth0={M278_vth0} u0={M278_u0} voff={M278_voff}
.model m_local_280 pmos level=8 version=3.3.0 vth0={M280_vth0} u0={M280_u0} voff={M280_voff}
.model m_local_281 pmos level=8 version=3.3.0 vth0={M281_vth0} u0={M281_u0} voff={M281_voff}
.model m_local_282 pmos level=8 version=3.3.0 vth0={M282_vth0} u0={M282_u0} voff={M282_voff}
.model m_local_286 pmos level=8 version=3.3.0 vth0={M286_vth0} u0={M286_u0} voff={M286_voff}
.model m_local_288 pmos level=8 version=3.3.0 vth0={M288_vth0} u0={M288_u0} voff={M288_voff}
.model m_local_289 pmos level=8 version=3.3.0 vth0={M289_vth0} u0={M289_u0} voff={M289_voff}
.model m_local_292 pmos level=8 version=3.3.0 vth0={M292_vth0} u0={M292_u0} voff={M292_voff}
.model m_local_294 pmos level=8 version=3.3.0 vth0={M294_vth0} u0={M294_u0} voff={M294_voff}
.model m_local_295 pmos level=8 version=3.3.0 vth0={M295_vth0} u0={M295_u0} voff={M295_voff}
.model m_local_296 pmos level=8 version=3.3.0 vth0={M296_vth0} u0={M296_u0} voff={M296_voff}
.model m_local_300 pmos level=8 version=3.3.0 vth0={M300_vth0} u0={M300_u0} voff={M300_voff}
.model m_local_302 pmos level=8 version=3.3.0 vth0={M302_vth0} u0={M302_u0} voff={M302_voff}
.model m_local_303 pmos level=8 version=3.3.0 vth0={M303_vth0} u0={M303_u0} voff={M303_voff}
.model m_local_306 pmos level=8 version=3.3.0 vth0={M306_vth0} u0={M306_u0} voff={M306_voff}
.model m_local_308 pmos level=8 version=3.3.0 vth0={M308_vth0} u0={M308_u0} voff={M308_voff}
.model m_local_309 pmos level=8 version=3.3.0 vth0={M309_vth0} u0={M309_u0} voff={M309_voff}
.model m_local_310 pmos level=8 version=3.3.0 vth0={M310_vth0} u0={M310_u0} voff={M310_voff}
.model m_local_314 pmos level=8 version=3.3.0 vth0={M314_vth0} u0={M314_u0} voff={M314_voff}
.model m_local_316 pmos level=8 version=3.3.0 vth0={M316_vth0} u0={M316_u0} voff={M316_voff}
.model m_local_317 pmos level=8 version=3.3.0 vth0={M317_vth0} u0={M317_u0} voff={M317_voff}
.model m_local_320 pmos level=8 version=3.3.0 vth0={M320_vth0} u0={M320_u0} voff={M320_voff}
.model m_local_322 pmos level=8 version=3.3.0 vth0={M322_vth0} u0={M322_u0} voff={M322_voff}
.model m_local_323 pmos level=8 version=3.3.0 vth0={M323_vth0} u0={M323_u0} voff={M323_voff}
.model m_local_324 pmos level=8 version=3.3.0 vth0={M324_vth0} u0={M324_u0} voff={M324_voff}
.model m_local_328 pmos level=8 version=3.3.0 vth0={M328_vth0} u0={M328_u0} voff={M328_voff}
.model m_local_330 pmos level=8 version=3.3.0 vth0={M330_vth0} u0={M330_u0} voff={M330_voff}
.model m_local_331 pmos level=8 version=3.3.0 vth0={M331_vth0} u0={M331_u0} voff={M331_voff}
.model m_local_334 pmos level=8 version=3.3.0 vth0={M334_vth0} u0={M334_u0} voff={M334_voff}
.model m_local_336 pmos level=8 version=3.3.0 vth0={M336_vth0} u0={M336_u0} voff={M336_voff}
.model m_local_337 pmos level=8 version=3.3.0 vth0={M337_vth0} u0={M337_u0} voff={M337_voff}
.model m_local_338 pmos level=8 version=3.3.0 vth0={M338_vth0} u0={M338_u0} voff={M338_voff}
.model m_local_342 pmos level=8 version=3.3.0 vth0={M342_vth0} u0={M342_u0} voff={M342_voff}
.model m_local_344 pmos level=8 version=3.3.0 vth0={M344_vth0} u0={M344_u0} voff={M344_voff}
.model m_local_345 pmos level=8 version=3.3.0 vth0={M345_vth0} u0={M345_u0} voff={M345_voff}
.model m_local_348 pmos level=8 version=3.3.0 vth0={M348_vth0} u0={M348_u0} voff={M348_voff}
.model m_local_350 pmos level=8 version=3.3.0 vth0={M350_vth0} u0={M350_u0} voff={M350_voff}
.model m_local_351 pmos level=8 version=3.3.0 vth0={M351_vth0} u0={M351_u0} voff={M351_voff}
.model m_local_352 pmos level=8 version=3.3.0 vth0={M352_vth0} u0={M352_u0} voff={M352_voff}
.model m_local_356 pmos level=8 version=3.3.0 vth0={M356_vth0} u0={M356_u0} voff={M356_voff}
.model m_local_358 pmos level=8 version=3.3.0 vth0={M358_vth0} u0={M358_u0} voff={M358_voff}
.model m_local_359 pmos level=8 version=3.3.0 vth0={M359_vth0} u0={M359_u0} voff={M359_voff}
.model m_local_362 pmos level=8 version=3.3.0 vth0={M362_vth0} u0={M362_u0} voff={M362_voff}
.model m_local_364 pmos level=8 version=3.3.0 vth0={M364_vth0} u0={M364_u0} voff={M364_voff}
.model m_local_365 pmos level=8 version=3.3.0 vth0={M365_vth0} u0={M365_u0} voff={M365_voff}
.model m_local_368 pmos level=8 version=3.3.0 vth0={M368_vth0} u0={M368_u0} voff={M368_voff}
.model m_local_370 pmos level=8 version=3.3.0 vth0={M370_vth0} u0={M370_u0} voff={M370_voff}
.model m_local_372 pmos level=8 version=3.3.0 vth0={M372_vth0} u0={M372_u0} voff={M372_voff}
.model m_local_373 pmos level=8 version=3.3.0 vth0={M373_vth0} u0={M373_u0} voff={M373_voff}
.model m_local_376 pmos level=8 version=3.3.0 vth0={M376_vth0} u0={M376_u0} voff={M376_voff}
.model m_local_377 pmos level=8 version=3.3.0 vth0={M377_vth0} u0={M377_u0} voff={M377_voff}
.model m_local_380 pmos level=8 version=3.3.0 vth0={M380_vth0} u0={M380_u0} voff={M380_voff}
.model m_local_381 pmos level=8 version=3.3.0 vth0={M381_vth0} u0={M381_u0} voff={M381_voff}
.model m_local_384 pmos level=8 version=3.3.0 vth0={M384_vth0} u0={M384_u0} voff={M384_voff}
.model m_local_385 pmos level=8 version=3.3.0 vth0={M385_vth0} u0={M385_u0} voff={M385_voff}
.model m_local_388 pmos level=8 version=3.3.0 vth0={M388_vth0} u0={M388_u0} voff={M388_voff}
.model m_local_389 pmos level=8 version=3.3.0 vth0={M389_vth0} u0={M389_u0} voff={M389_voff}
.model m_local_390 pmos level=8 version=3.3.0 vth0={M390_vth0} u0={M390_u0} voff={M390_voff}
.model m_local_391 pmos level=8 version=3.3.0 vth0={M391_vth0} u0={M391_u0} voff={M391_voff}
.model m_local_392 pmos level=8 version=3.3.0 vth0={M392_vth0} u0={M392_u0} voff={M392_voff}
.model m_local_393 pmos level=8 version=3.3.0 vth0={M393_vth0} u0={M393_u0} voff={M393_voff}
.model m_local_395 pmos level=8 version=3.3.0 vth0={M395_vth0} u0={M395_u0} voff={M395_voff}
.model m_local_397 pmos level=8 version=3.3.0 vth0={M397_vth0} u0={M397_u0} voff={M397_voff}
.model m_local_398 pmos level=8 version=3.3.0 vth0={M398_vth0} u0={M398_u0} voff={M398_voff}
.model m_local_399 pmos level=8 version=3.3.0 vth0={M399_vth0} u0={M399_u0} voff={M399_voff}
.model m_local_0 nmos level=8 version=3.3.0 vth0={M0_vth0} u0={M0_u0} voff={M0_voff}
.model m_local_1 nmos level=8 version=3.3.0 vth0={M1_vth0} u0={M1_u0} voff={M1_voff}
.model m_local_2 nmos level=8 version=3.3.0 vth0={M2_vth0} u0={M2_u0} voff={M2_voff}
.model m_local_3 nmos level=8 version=3.3.0 vth0={M3_vth0} u0={M3_u0} voff={M3_voff}
.model m_local_6 nmos level=8 version=3.3.0 vth0={M6_vth0} u0={M6_u0} voff={M6_voff}
.model m_local_7 nmos level=8 version=3.3.0 vth0={M7_vth0} u0={M7_u0} voff={M7_voff}
.model m_local_8 nmos level=8 version=3.3.0 vth0={M8_vth0} u0={M8_u0} voff={M8_voff}
.model m_local_10 nmos level=8 version=3.3.0 vth0={M10_vth0} u0={M10_u0} voff={M10_voff}
.model m_local_12 nmos level=8 version=3.3.0 vth0={M12_vth0} u0={M12_u0} voff={M12_voff}
.model m_local_13 nmos level=8 version=3.3.0 vth0={M13_vth0} u0={M13_u0} voff={M13_voff}
.model m_local_14 nmos level=8 version=3.3.0 vth0={M14_vth0} u0={M14_u0} voff={M14_voff}
.model m_local_16 nmos level=8 version=3.3.0 vth0={M16_vth0} u0={M16_u0} voff={M16_voff}
.model m_local_20 nmos level=8 version=3.3.0 vth0={M20_vth0} u0={M20_u0} voff={M20_voff}
.model m_local_21 nmos level=8 version=3.3.0 vth0={M21_vth0} u0={M21_u0} voff={M21_voff}
.model m_local_23 nmos level=8 version=3.3.0 vth0={M23_vth0} u0={M23_u0} voff={M23_voff}
.model m_local_25 nmos level=8 version=3.3.0 vth0={M25_vth0} u0={M25_u0} voff={M25_voff}
.model m_local_27 nmos level=8 version=3.3.0 vth0={M27_vth0} u0={M27_u0} voff={M27_voff}
.model m_local_29 nmos level=8 version=3.3.0 vth0={M29_vth0} u0={M29_u0} voff={M29_voff}
.model m_local_31 nmos level=8 version=3.3.0 vth0={M31_vth0} u0={M31_u0} voff={M31_voff}
.model m_local_33 nmos level=8 version=3.3.0 vth0={M33_vth0} u0={M33_u0} voff={M33_voff}
.model m_local_35 nmos level=8 version=3.3.0 vth0={M35_vth0} u0={M35_u0} voff={M35_voff}
.model m_local_37 nmos level=8 version=3.3.0 vth0={M37_vth0} u0={M37_u0} voff={M37_voff}
.model m_local_39 nmos level=8 version=3.3.0 vth0={M39_vth0} u0={M39_u0} voff={M39_voff}
.model m_local_41 nmos level=8 version=3.3.0 vth0={M41_vth0} u0={M41_u0} voff={M41_voff}
.model m_local_43 nmos level=8 version=3.3.0 vth0={M43_vth0} u0={M43_u0} voff={M43_voff}
.model m_local_45 nmos level=8 version=3.3.0 vth0={M45_vth0} u0={M45_u0} voff={M45_voff}
.model m_local_47 nmos level=8 version=3.3.0 vth0={M47_vth0} u0={M47_u0} voff={M47_voff}
.model m_local_49 nmos level=8 version=3.3.0 vth0={M49_vth0} u0={M49_u0} voff={M49_voff}
.model m_local_51 nmos level=8 version=3.3.0 vth0={M51_vth0} u0={M51_u0} voff={M51_voff}
.model m_local_53 nmos level=8 version=3.3.0 vth0={M53_vth0} u0={M53_u0} voff={M53_voff}
.model m_local_55 nmos level=8 version=3.3.0 vth0={M55_vth0} u0={M55_u0} voff={M55_voff}
.model m_local_57 nmos level=8 version=3.3.0 vth0={M57_vth0} u0={M57_u0} voff={M57_voff}
.model m_local_59 nmos level=8 version=3.3.0 vth0={M59_vth0} u0={M59_u0} voff={M59_voff}
.model m_local_61 nmos level=8 version=3.3.0 vth0={M61_vth0} u0={M61_u0} voff={M61_voff}
.model m_local_63 nmos level=8 version=3.3.0 vth0={M63_vth0} u0={M63_u0} voff={M63_voff}
.model m_local_65 nmos level=8 version=3.3.0 vth0={M65_vth0} u0={M65_u0} voff={M65_voff}
.model m_local_67 nmos level=8 version=3.3.0 vth0={M67_vth0} u0={M67_u0} voff={M67_voff}
.model m_local_69 nmos level=8 version=3.3.0 vth0={M69_vth0} u0={M69_u0} voff={M69_voff}
.model m_local_71 nmos level=8 version=3.3.0 vth0={M71_vth0} u0={M71_u0} voff={M71_voff}
.model m_local_73 nmos level=8 version=3.3.0 vth0={M73_vth0} u0={M73_u0} voff={M73_voff}
.model m_local_75 nmos level=8 version=3.3.0 vth0={M75_vth0} u0={M75_u0} voff={M75_voff}
.model m_local_77 nmos level=8 version=3.3.0 vth0={M77_vth0} u0={M77_u0} voff={M77_voff}
.model m_local_79 nmos level=8 version=3.3.0 vth0={M79_vth0} u0={M79_u0} voff={M79_voff}
.model m_local_81 nmos level=8 version=3.3.0 vth0={M81_vth0} u0={M81_u0} voff={M81_voff}
.model m_local_83 nmos level=8 version=3.3.0 vth0={M83_vth0} u0={M83_u0} voff={M83_voff}
.model m_local_85 nmos level=8 version=3.3.0 vth0={M85_vth0} u0={M85_u0} voff={M85_voff}
.model m_local_87 nmos level=8 version=3.3.0 vth0={M87_vth0} u0={M87_u0} voff={M87_voff}
.model m_local_89 nmos level=8 version=3.3.0 vth0={M89_vth0} u0={M89_u0} voff={M89_voff}
.model m_local_91 nmos level=8 version=3.3.0 vth0={M91_vth0} u0={M91_u0} voff={M91_voff}
.model m_local_93 nmos level=8 version=3.3.0 vth0={M93_vth0} u0={M93_u0} voff={M93_voff}
.model m_local_95 nmos level=8 version=3.3.0 vth0={M95_vth0} u0={M95_u0} voff={M95_voff}
.model m_local_97 nmos level=8 version=3.3.0 vth0={M97_vth0} u0={M97_u0} voff={M97_voff}
.model m_local_99 nmos level=8 version=3.3.0 vth0={M99_vth0} u0={M99_u0} voff={M99_voff}
.model m_local_101 nmos level=8 version=3.3.0 vth0={M101_vth0} u0={M101_u0} voff={M101_voff}
.model m_local_103 nmos level=8 version=3.3.0 vth0={M103_vth0} u0={M103_u0} voff={M103_voff}
.model m_local_105 nmos level=8 version=3.3.0 vth0={M105_vth0} u0={M105_u0} voff={M105_voff}
.model m_local_107 nmos level=8 version=3.3.0 vth0={M107_vth0} u0={M107_u0} voff={M107_voff}
.model m_local_110 nmos level=8 version=3.3.0 vth0={M110_vth0} u0={M110_u0} voff={M110_voff}
.model m_local_111 nmos level=8 version=3.3.0 vth0={M111_vth0} u0={M111_u0} voff={M111_voff}
.model m_local_113 nmos level=8 version=3.3.0 vth0={M113_vth0} u0={M113_u0} voff={M113_voff}
.model m_local_116 nmos level=8 version=3.3.0 vth0={M116_vth0} u0={M116_u0} voff={M116_voff}
.model m_local_117 nmos level=8 version=3.3.0 vth0={M117_vth0} u0={M117_u0} voff={M117_voff}
.model m_local_119 nmos level=8 version=3.3.0 vth0={M119_vth0} u0={M119_u0} voff={M119_voff}
.model m_local_121 nmos level=8 version=3.3.0 vth0={M121_vth0} u0={M121_u0} voff={M121_voff}
.model m_local_123 nmos level=8 version=3.3.0 vth0={M123_vth0} u0={M123_u0} voff={M123_voff}
.model m_local_125 nmos level=8 version=3.3.0 vth0={M125_vth0} u0={M125_u0} voff={M125_voff}
.model m_local_127 nmos level=8 version=3.3.0 vth0={M127_vth0} u0={M127_u0} voff={M127_voff}
.model m_local_129 nmos level=8 version=3.3.0 vth0={M129_vth0} u0={M129_u0} voff={M129_voff}
.model m_local_131 nmos level=8 version=3.3.0 vth0={M131_vth0} u0={M131_u0} voff={M131_voff}
.model m_local_133 nmos level=8 version=3.3.0 vth0={M133_vth0} u0={M133_u0} voff={M133_voff}
.model m_local_135 nmos level=8 version=3.3.0 vth0={M135_vth0} u0={M135_u0} voff={M135_voff}
.model m_local_137 nmos level=8 version=3.3.0 vth0={M137_vth0} u0={M137_u0} voff={M137_voff}
.model m_local_139 nmos level=8 version=3.3.0 vth0={M139_vth0} u0={M139_u0} voff={M139_voff}
.model m_local_141 nmos level=8 version=3.3.0 vth0={M141_vth0} u0={M141_u0} voff={M141_voff}
.model m_local_143 nmos level=8 version=3.3.0 vth0={M143_vth0} u0={M143_u0} voff={M143_voff}
.model m_local_145 nmos level=8 version=3.3.0 vth0={M145_vth0} u0={M145_u0} voff={M145_voff}
.model m_local_147 nmos level=8 version=3.3.0 vth0={M147_vth0} u0={M147_u0} voff={M147_voff}
.model m_local_149 nmos level=8 version=3.3.0 vth0={M149_vth0} u0={M149_u0} voff={M149_voff}
.model m_local_151 nmos level=8 version=3.3.0 vth0={M151_vth0} u0={M151_u0} voff={M151_voff}
.model m_local_153 nmos level=8 version=3.3.0 vth0={M153_vth0} u0={M153_u0} voff={M153_voff}
.model m_local_155 nmos level=8 version=3.3.0 vth0={M155_vth0} u0={M155_u0} voff={M155_voff}
.model m_local_157 nmos level=8 version=3.3.0 vth0={M157_vth0} u0={M157_u0} voff={M157_voff}
.model m_local_159 nmos level=8 version=3.3.0 vth0={M159_vth0} u0={M159_u0} voff={M159_voff}
.model m_local_161 nmos level=8 version=3.3.0 vth0={M161_vth0} u0={M161_u0} voff={M161_voff}
.model m_local_163 nmos level=8 version=3.3.0 vth0={M163_vth0} u0={M163_u0} voff={M163_voff}
.model m_local_165 nmos level=8 version=3.3.0 vth0={M165_vth0} u0={M165_u0} voff={M165_voff}
.model m_local_167 nmos level=8 version=3.3.0 vth0={M167_vth0} u0={M167_u0} voff={M167_voff}
.model m_local_169 nmos level=8 version=3.3.0 vth0={M169_vth0} u0={M169_u0} voff={M169_voff}
.model m_local_171 nmos level=8 version=3.3.0 vth0={M171_vth0} u0={M171_u0} voff={M171_voff}
.model m_local_173 nmos level=8 version=3.3.0 vth0={M173_vth0} u0={M173_u0} voff={M173_voff}
.model m_local_175 nmos level=8 version=3.3.0 vth0={M175_vth0} u0={M175_u0} voff={M175_voff}
.model m_local_177 nmos level=8 version=3.3.0 vth0={M177_vth0} u0={M177_u0} voff={M177_voff}
.model m_local_179 nmos level=8 version=3.3.0 vth0={M179_vth0} u0={M179_u0} voff={M179_voff}
.model m_local_181 nmos level=8 version=3.3.0 vth0={M181_vth0} u0={M181_u0} voff={M181_voff}
.model m_local_183 nmos level=8 version=3.3.0 vth0={M183_vth0} u0={M183_u0} voff={M183_voff}
.model m_local_185 nmos level=8 version=3.3.0 vth0={M185_vth0} u0={M185_u0} voff={M185_voff}
.model m_local_187 nmos level=8 version=3.3.0 vth0={M187_vth0} u0={M187_u0} voff={M187_voff}
.model m_local_189 nmos level=8 version=3.3.0 vth0={M189_vth0} u0={M189_u0} voff={M189_voff}
.model m_local_191 nmos level=8 version=3.3.0 vth0={M191_vth0} u0={M191_u0} voff={M191_voff}
.model m_local_193 nmos level=8 version=3.3.0 vth0={M193_vth0} u0={M193_u0} voff={M193_voff}
.model m_local_195 nmos level=8 version=3.3.0 vth0={M195_vth0} u0={M195_u0} voff={M195_voff}
.model m_local_197 nmos level=8 version=3.3.0 vth0={M197_vth0} u0={M197_u0} voff={M197_voff}
.model m_local_199 nmos level=8 version=3.3.0 vth0={M199_vth0} u0={M199_u0} voff={M199_voff}
.model m_local_201 nmos level=8 version=3.3.0 vth0={M201_vth0} u0={M201_u0} voff={M201_voff}
.model m_local_203 nmos level=8 version=3.3.0 vth0={M203_vth0} u0={M203_u0} voff={M203_voff}
.model m_local_205 nmos level=8 version=3.3.0 vth0={M205_vth0} u0={M205_u0} voff={M205_voff}
.model m_local_207 nmos level=8 version=3.3.0 vth0={M207_vth0} u0={M207_u0} voff={M207_voff}
.model m_local_209 nmos level=8 version=3.3.0 vth0={M209_vth0} u0={M209_u0} voff={M209_voff}
.model m_local_211 nmos level=8 version=3.3.0 vth0={M211_vth0} u0={M211_u0} voff={M211_voff}
.model m_local_213 nmos level=8 version=3.3.0 vth0={M213_vth0} u0={M213_u0} voff={M213_voff}
.model m_local_215 nmos level=8 version=3.3.0 vth0={M215_vth0} u0={M215_u0} voff={M215_voff}
.model m_local_217 nmos level=8 version=3.3.0 vth0={M217_vth0} u0={M217_u0} voff={M217_voff}
.model m_local_221 nmos level=8 version=3.3.0 vth0={M221_vth0} u0={M221_u0} voff={M221_voff}
.model m_local_222 nmos level=8 version=3.3.0 vth0={M222_vth0} u0={M222_u0} voff={M222_voff}
.model m_local_223 nmos level=8 version=3.3.0 vth0={M223_vth0} u0={M223_u0} voff={M223_voff}
.model m_local_225 nmos level=8 version=3.3.0 vth0={M225_vth0} u0={M225_u0} voff={M225_voff}
.model m_local_229 nmos level=8 version=3.3.0 vth0={M229_vth0} u0={M229_u0} voff={M229_voff}
.model m_local_230 nmos level=8 version=3.3.0 vth0={M230_vth0} u0={M230_u0} voff={M230_voff}
.model m_local_231 nmos level=8 version=3.3.0 vth0={M231_vth0} u0={M231_u0} voff={M231_voff}
.model m_local_233 nmos level=8 version=3.3.0 vth0={M233_vth0} u0={M233_u0} voff={M233_voff}
.model m_local_237 nmos level=8 version=3.3.0 vth0={M237_vth0} u0={M237_u0} voff={M237_voff}
.model m_local_238 nmos level=8 version=3.3.0 vth0={M238_vth0} u0={M238_u0} voff={M238_voff}
.model m_local_239 nmos level=8 version=3.3.0 vth0={M239_vth0} u0={M239_u0} voff={M239_voff}
.model m_local_241 nmos level=8 version=3.3.0 vth0={M241_vth0} u0={M241_u0} voff={M241_voff}
.model m_local_243 nmos level=8 version=3.3.0 vth0={M243_vth0} u0={M243_u0} voff={M243_voff}
.model m_local_245 nmos level=8 version=3.3.0 vth0={M245_vth0} u0={M245_u0} voff={M245_voff}
.model m_local_247 nmos level=8 version=3.3.0 vth0={M247_vth0} u0={M247_u0} voff={M247_voff}
.model m_local_249 nmos level=8 version=3.3.0 vth0={M249_vth0} u0={M249_u0} voff={M249_voff}
.model m_local_251 nmos level=8 version=3.3.0 vth0={M251_vth0} u0={M251_u0} voff={M251_voff}
.model m_local_255 nmos level=8 version=3.3.0 vth0={M255_vth0} u0={M255_u0} voff={M255_voff}
.model m_local_256 nmos level=8 version=3.3.0 vth0={M256_vth0} u0={M256_u0} voff={M256_voff}
.model m_local_257 nmos level=8 version=3.3.0 vth0={M257_vth0} u0={M257_u0} voff={M257_voff}
.model m_local_259 nmos level=8 version=3.3.0 vth0={M259_vth0} u0={M259_u0} voff={M259_voff}
.model m_local_262 nmos level=8 version=3.3.0 vth0={M262_vth0} u0={M262_u0} voff={M262_voff}
.model m_local_263 nmos level=8 version=3.3.0 vth0={M263_vth0} u0={M263_u0} voff={M263_voff}
.model m_local_265 nmos level=8 version=3.3.0 vth0={M265_vth0} u0={M265_u0} voff={M265_voff}
.model m_local_269 nmos level=8 version=3.3.0 vth0={M269_vth0} u0={M269_u0} voff={M269_voff}
.model m_local_270 nmos level=8 version=3.3.0 vth0={M270_vth0} u0={M270_u0} voff={M270_voff}
.model m_local_271 nmos level=8 version=3.3.0 vth0={M271_vth0} u0={M271_u0} voff={M271_voff}
.model m_local_273 nmos level=8 version=3.3.0 vth0={M273_vth0} u0={M273_u0} voff={M273_voff}
.model m_local_276 nmos level=8 version=3.3.0 vth0={M276_vth0} u0={M276_u0} voff={M276_voff}
.model m_local_277 nmos level=8 version=3.3.0 vth0={M277_vth0} u0={M277_u0} voff={M277_voff}
.model m_local_279 nmos level=8 version=3.3.0 vth0={M279_vth0} u0={M279_u0} voff={M279_voff}
.model m_local_283 nmos level=8 version=3.3.0 vth0={M283_vth0} u0={M283_u0} voff={M283_voff}
.model m_local_284 nmos level=8 version=3.3.0 vth0={M284_vth0} u0={M284_u0} voff={M284_voff}
.model m_local_285 nmos level=8 version=3.3.0 vth0={M285_vth0} u0={M285_u0} voff={M285_voff}
.model m_local_287 nmos level=8 version=3.3.0 vth0={M287_vth0} u0={M287_u0} voff={M287_voff}
.model m_local_290 nmos level=8 version=3.3.0 vth0={M290_vth0} u0={M290_u0} voff={M290_voff}
.model m_local_291 nmos level=8 version=3.3.0 vth0={M291_vth0} u0={M291_u0} voff={M291_voff}
.model m_local_293 nmos level=8 version=3.3.0 vth0={M293_vth0} u0={M293_u0} voff={M293_voff}
.model m_local_297 nmos level=8 version=3.3.0 vth0={M297_vth0} u0={M297_u0} voff={M297_voff}
.model m_local_298 nmos level=8 version=3.3.0 vth0={M298_vth0} u0={M298_u0} voff={M298_voff}
.model m_local_299 nmos level=8 version=3.3.0 vth0={M299_vth0} u0={M299_u0} voff={M299_voff}
.model m_local_301 nmos level=8 version=3.3.0 vth0={M301_vth0} u0={M301_u0} voff={M301_voff}
.model m_local_304 nmos level=8 version=3.3.0 vth0={M304_vth0} u0={M304_u0} voff={M304_voff}
.model m_local_305 nmos level=8 version=3.3.0 vth0={M305_vth0} u0={M305_u0} voff={M305_voff}
.model m_local_307 nmos level=8 version=3.3.0 vth0={M307_vth0} u0={M307_u0} voff={M307_voff}
.model m_local_311 nmos level=8 version=3.3.0 vth0={M311_vth0} u0={M311_u0} voff={M311_voff}
.model m_local_312 nmos level=8 version=3.3.0 vth0={M312_vth0} u0={M312_u0} voff={M312_voff}
.model m_local_313 nmos level=8 version=3.3.0 vth0={M313_vth0} u0={M313_u0} voff={M313_voff}
.model m_local_315 nmos level=8 version=3.3.0 vth0={M315_vth0} u0={M315_u0} voff={M315_voff}
.model m_local_318 nmos level=8 version=3.3.0 vth0={M318_vth0} u0={M318_u0} voff={M318_voff}
.model m_local_319 nmos level=8 version=3.3.0 vth0={M319_vth0} u0={M319_u0} voff={M319_voff}
.model m_local_321 nmos level=8 version=3.3.0 vth0={M321_vth0} u0={M321_u0} voff={M321_voff}
.model m_local_325 nmos level=8 version=3.3.0 vth0={M325_vth0} u0={M325_u0} voff={M325_voff}
.model m_local_326 nmos level=8 version=3.3.0 vth0={M326_vth0} u0={M326_u0} voff={M326_voff}
.model m_local_327 nmos level=8 version=3.3.0 vth0={M327_vth0} u0={M327_u0} voff={M327_voff}
.model m_local_329 nmos level=8 version=3.3.0 vth0={M329_vth0} u0={M329_u0} voff={M329_voff}
.model m_local_332 nmos level=8 version=3.3.0 vth0={M332_vth0} u0={M332_u0} voff={M332_voff}
.model m_local_333 nmos level=8 version=3.3.0 vth0={M333_vth0} u0={M333_u0} voff={M333_voff}
.model m_local_335 nmos level=8 version=3.3.0 vth0={M335_vth0} u0={M335_u0} voff={M335_voff}
.model m_local_339 nmos level=8 version=3.3.0 vth0={M339_vth0} u0={M339_u0} voff={M339_voff}
.model m_local_340 nmos level=8 version=3.3.0 vth0={M340_vth0} u0={M340_u0} voff={M340_voff}
.model m_local_341 nmos level=8 version=3.3.0 vth0={M341_vth0} u0={M341_u0} voff={M341_voff}
.model m_local_343 nmos level=8 version=3.3.0 vth0={M343_vth0} u0={M343_u0} voff={M343_voff}
.model m_local_346 nmos level=8 version=3.3.0 vth0={M346_vth0} u0={M346_u0} voff={M346_voff}
.model m_local_347 nmos level=8 version=3.3.0 vth0={M347_vth0} u0={M347_u0} voff={M347_voff}
.model m_local_349 nmos level=8 version=3.3.0 vth0={M349_vth0} u0={M349_u0} voff={M349_voff}
.model m_local_353 nmos level=8 version=3.3.0 vth0={M353_vth0} u0={M353_u0} voff={M353_voff}
.model m_local_354 nmos level=8 version=3.3.0 vth0={M354_vth0} u0={M354_u0} voff={M354_voff}
.model m_local_355 nmos level=8 version=3.3.0 vth0={M355_vth0} u0={M355_u0} voff={M355_voff}
.model m_local_357 nmos level=8 version=3.3.0 vth0={M357_vth0} u0={M357_u0} voff={M357_voff}
.model m_local_360 nmos level=8 version=3.3.0 vth0={M360_vth0} u0={M360_u0} voff={M360_voff}
.model m_local_361 nmos level=8 version=3.3.0 vth0={M361_vth0} u0={M361_u0} voff={M361_voff}
.model m_local_363 nmos level=8 version=3.3.0 vth0={M363_vth0} u0={M363_u0} voff={M363_voff}
.model m_local_366 nmos level=8 version=3.3.0 vth0={M366_vth0} u0={M366_u0} voff={M366_voff}
.model m_local_367 nmos level=8 version=3.3.0 vth0={M367_vth0} u0={M367_u0} voff={M367_voff}
.model m_local_369 nmos level=8 version=3.3.0 vth0={M369_vth0} u0={M369_u0} voff={M369_voff}
.model m_local_371 nmos level=8 version=3.3.0 vth0={M371_vth0} u0={M371_u0} voff={M371_voff}
.model m_local_374 nmos level=8 version=3.3.0 vth0={M374_vth0} u0={M374_u0} voff={M374_voff}
.model m_local_375 nmos level=8 version=3.3.0 vth0={M375_vth0} u0={M375_u0} voff={M375_voff}
.model m_local_378 nmos level=8 version=3.3.0 vth0={M378_vth0} u0={M378_u0} voff={M378_voff}
.model m_local_379 nmos level=8 version=3.3.0 vth0={M379_vth0} u0={M379_u0} voff={M379_voff}
.model m_local_382 nmos level=8 version=3.3.0 vth0={M382_vth0} u0={M382_u0} voff={M382_voff}
.model m_local_383 nmos level=8 version=3.3.0 vth0={M383_vth0} u0={M383_u0} voff={M383_voff}
.model m_local_386 nmos level=8 version=3.3.0 vth0={M386_vth0} u0={M386_u0} voff={M386_voff}
.model m_local_387 nmos level=8 version=3.3.0 vth0={M387_vth0} u0={M387_u0} voff={M387_voff}
.model m_local_394 nmos level=8 version=3.3.0 vth0={M394_vth0} u0={M394_u0} voff={M394_voff}
.model m_local_396 nmos level=8 version=3.3.0 vth0={M396_vth0} u0={M396_u0} voff={M396_voff}
.model m_local_400 nmos level=8 version=3.3.0 vth0={M400_vth0} u0={M400_u0} voff={M400_voff}
