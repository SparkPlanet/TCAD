* title: SRAM_6T_CORE_1x1_TB
.include "surrogate_nfet_freepdk45.spice"
.include "surrogate_pfet_freepdk45.spice"
.include "params.sp"

VVDD VDD VSS 1.0
VVSS VSS 0 0
Xmos_0 bl0 wl0 xsram_6t_core_1x1.xsram_6t_cell_0_0.q vss surrogate_nfet_freepdk45 l=5e-08 w=1.35e-07 scale_vth0={M0_vth0} scale_u0={M0_u0} scale_voff={M0_voff} * xsram_6t_core_1x1.xsram_6t_cell_0_0.mpgl
Xmos_1 blb0 wl0 xsram_6t_core_1x1.xsram_6t_cell_0_0.qb vss surrogate_nfet_freepdk45 l=5e-08 w=1.35e-07 scale_vth0={M1_vth0} scale_u0={M1_u0} scale_voff={M1_voff} * xsram_6t_core_1x1.xsram_6t_cell_0_0.mpgr
Xmos_2 xsram_6t_core_1x1.xsram_6t_cell_0_0.q xsram_6t_core_1x1.xsram_6t_cell_0_0.qb vss vss surrogate_nfet_freepdk45 l=5e-08 w=2.05e-07 scale_vth0={M2_vth0} scale_u0={M2_u0} scale_voff={M2_voff} * xsram_6t_core_1x1.xsram_6t_cell_0_0.mpdl
Xmos_3 xsram_6t_core_1x1.xsram_6t_cell_0_0.qb xsram_6t_core_1x1.xsram_6t_cell_0_0.q vss vss surrogate_nfet_freepdk45 l=5e-08 w=2.05e-07 scale_vth0={M3_vth0} scale_u0={M3_u0} scale_voff={M3_voff} * xsram_6t_core_1x1.xsram_6t_cell_0_0.mpdr
Xmos_4 xsram_6t_core_1x1.xsram_6t_cell_0_0.q xsram_6t_core_1x1.xsram_6t_cell_0_0.qb vdd vdd surrogate_pfet_freepdk45 l=5e-08 w=9e-08 scale_vth0={M4_vth0} scale_u0={M4_u0} scale_voff={M4_voff} * xsram_6t_core_1x1.xsram_6t_cell_0_0.mpul
Xmos_5 xsram_6t_core_1x1.xsram_6t_cell_0_0.qb xsram_6t_core_1x1.xsram_6t_cell_0_0.q vdd vdd surrogate_pfet_freepdk45 l=5e-08 w=9e-08 scale_vth0={M5_vth0} scale_u0={M5_u0} scale_voff={M5_voff} * xsram_6t_core_1x1.xsram_6t_cell_0_0.mpur
Xmos_6 rbl rwl xsram_17x1_replica_column.xreplica_cell_0.q vss surrogate_nfet_freepdk45 l=5e-08 w=1.35e-07 scale_vth0={M6_vth0} scale_u0={M6_u0} scale_voff={M6_voff} * xsram_17x1_replica_column.xreplica_cell_0.mpgl
Xmos_7 rblb rwl vdd vss surrogate_nfet_freepdk45 l=5e-08 w=1.35e-07 scale_vth0={M7_vth0} scale_u0={M7_u0} scale_voff={M7_voff} * xsram_17x1_replica_column.xreplica_cell_0.mpgr
Xmos_8 xsram_17x1_replica_column.xreplica_cell_0.q vdd vss vss surrogate_nfet_freepdk45 l=5e-08 w=2.05e-07 scale_vth0={M8_vth0} scale_u0={M8_u0} scale_voff={M8_voff} * xsram_17x1_replica_column.xreplica_cell_0.mpdl
Xmos_9 xsram_17x1_replica_column.xreplica_cell_0.q vdd vdd vdd surrogate_pfet_freepdk45 l=5e-08 w=9e-08 scale_vth0={M9_vth0} scale_u0={M9_u0} scale_voff={M9_voff} * xsram_17x1_replica_column.xreplica_cell_0.mpul
Xmos_10 vdd xsram_17x1_replica_column.xreplica_cell_0.q vss vss surrogate_nfet_freepdk45 l=5e-08 w=2.05e-07 scale_vth0={M10_vth0} scale_u0={M10_u0} scale_voff={M10_voff} * xsram_17x1_replica_column.xreplica_cell_0.mpdr
Xmos_11 vdd xsram_17x1_replica_column.xreplica_cell_0.q vdd vdd surrogate_pfet_freepdk45 l=5e-08 w=9e-08 scale_vth0={M11_vth0} scale_u0={M11_u0} scale_voff={M11_voff} * xsram_17x1_replica_column.xreplica_cell_0.mpur
Xmos_12 rbl wl0 xsram_17x1_replica_column.xreplica_cell_1.q vss surrogate_nfet_freepdk45 l=5e-08 w=1.35e-07 scale_vth0={M12_vth0} scale_u0={M12_u0} scale_voff={M12_voff} * xsram_17x1_replica_column.xreplica_cell_1.mpgl
Xmos_13 rblb wl0 vdd vss surrogate_nfet_freepdk45 l=5e-08 w=1.35e-07 scale_vth0={M13_vth0} scale_u0={M13_u0} scale_voff={M13_voff} * xsram_17x1_replica_column.xreplica_cell_1.mpgr
Xmos_14 xsram_17x1_replica_column.xreplica_cell_1.q vdd vss vss surrogate_nfet_freepdk45 l=5e-08 w=2.05e-07 scale_vth0={M14_vth0} scale_u0={M14_u0} scale_voff={M14_voff} * xsram_17x1_replica_column.xreplica_cell_1.mpdl
Xmos_15 xsram_17x1_replica_column.xreplica_cell_1.q vdd vdd vdd surrogate_pfet_freepdk45 l=5e-08 w=9e-08 scale_vth0={M15_vth0} scale_u0={M15_u0} scale_voff={M15_voff} * xsram_17x1_replica_column.xreplica_cell_1.mpul
Xmos_16 vdd xsram_17x1_replica_column.xreplica_cell_1.q vss vss surrogate_nfet_freepdk45 l=5e-08 w=2.05e-07 scale_vth0={M16_vth0} scale_u0={M16_u0} scale_voff={M16_voff} * xsram_17x1_replica_column.xreplica_cell_1.mpdr
Xmos_17 vdd xsram_17x1_replica_column.xreplica_cell_1.q vdd vdd surrogate_pfet_freepdk45 l=5e-08 w=9e-08 scale_vth0={M17_vth0} scale_u0={M17_u0} scale_voff={M17_voff} * xsram_17x1_replica_column.xreplica_cell_1.mpur
Xmos_18 xrwl.zb_int wl_en vdd vdd surrogate_pfet_freepdk45 l=5e-08 w=2.7e-07 scale_vth0={M18_vth0} scale_u0={M18_u0} scale_voff={M18_voff} * xrwl.xpnand3.mpnand2_pmos1
Xmos_19 xrwl.zb_int vdd vdd vdd surrogate_pfet_freepdk45 l=5e-08 w=2.7e-07 scale_vth0={M19_vth0} scale_u0={M19_u0} scale_voff={M19_voff} * xrwl.xpnand3.mpnand2_pmos2
Xmos_20 xrwl.zb_int vdd xrwl.xpnand3.net1 vss surrogate_nfet_freepdk45 l=5e-08 w=1.8e-07 scale_vth0={M20_vth0} scale_u0={M20_u0} scale_voff={M20_voff} * xrwl.xpnand3.mpnand2_nmos1
Xmos_21 xrwl.xpnand3.net1 wl_en vss vss surrogate_nfet_freepdk45 l=5e-08 w=1.8e-07 scale_vth0={M21_vth0} scale_u0={M21_u0} scale_voff={M21_voff} * xrwl.xpnand3.mpnand2_nmos2
Xmos_22 rwl xrwl.zb_int vdd vdd surrogate_pfet_freepdk45 l=5e-08 w=2.7e-07 scale_vth0={M22_vth0} scale_u0={M22_u0} scale_voff={M22_voff} * xrwl.xpinv.mpinv_pmos
Xmos_23 rwl xrwl.zb_int vss vss surrogate_nfet_freepdk45 l=5e-08 w=9e-08 scale_vth0={M23_vth0} scale_u0={M23_u0} scale_voff={M23_voff} * xrwl.xpinv.mpinv_nmos
Xmos_24 xtime.xdff_buf_addr.xdff_0.clkb clk_buf vdd vdd surrogate_pfet_freepdk45 l=5e-08 w=5e-07 scale_vth0={M24_vth0} scale_u0={M24_u0} scale_voff={M24_voff} * xtime.xdff_buf_addr.xdff_0.xinv1_clk.mpinv_pmos
Xmos_25 xtime.xdff_buf_addr.xdff_0.clkb clk_buf vss vss surrogate_nfet_freepdk45 l=5e-08 w=2.5e-07 scale_vth0={M25_vth0} scale_u0={M25_u0} scale_voff={M25_voff} * xtime.xdff_buf_addr.xdff_0.xinv1_clk.mpinv_nmos
Xmos_26 xtime.xdff_buf_addr.xdff_0.d_b a0 vdd vdd surrogate_pfet_freepdk45 l=5e-08 w=5e-07 scale_vth0={M26_vth0} scale_u0={M26_u0} scale_voff={M26_voff} * xtime.xdff_buf_addr.xdff_0.xinv2_d.mpinv_pmos
Xmos_27 xtime.xdff_buf_addr.xdff_0.d_b a0 vss vss surrogate_nfet_freepdk45 l=5e-08 w=2.5e-07 scale_vth0={M27_vth0} scale_u0={M27_u0} scale_voff={M27_voff} * xtime.xdff_buf_addr.xdff_0.xinv2_d.mpinv_nmos
Xmos_28 xtime.xdff_buf_addr.xdff_0.z1 clk_buf xtime.xdff_buf_addr.xdff_0.d_b vdd surrogate_pfet_freepdk45 l=5e-08 w=5e-07 scale_vth0={M28_vth0} scale_u0={M28_u0} scale_voff={M28_voff} * xtime.xdff_buf_addr.xdff_0.xtg1.mtranspmos
Xmos_29 xtime.xdff_buf_addr.xdff_0.d_b xtime.xdff_buf_addr.xdff_0.clkb xtime.xdff_buf_addr.xdff_0.z1 vss surrogate_nfet_freepdk45 l=5e-08 w=2.5e-07 scale_vth0={M29_vth0} scale_u0={M29_u0} scale_voff={M29_voff} * xtime.xdff_buf_addr.xdff_0.xtg1.mtransnmos
Xmos_30 xtime.xdff_buf_addr.xdff_0.z2 xtime.xdff_buf_addr.xdff_0.z1 vdd vdd surrogate_pfet_freepdk45 l=5e-08 w=5e-07 scale_vth0={M30_vth0} scale_u0={M30_u0} scale_voff={M30_voff} * xtime.xdff_buf_addr.xdff_0.xinv3.mpinv_pmos
Xmos_31 xtime.xdff_buf_addr.xdff_0.z2 xtime.xdff_buf_addr.xdff_0.z1 vss vss surrogate_nfet_freepdk45 l=5e-08 w=2.5e-07 scale_vth0={M31_vth0} scale_u0={M31_u0} scale_voff={M31_voff} * xtime.xdff_buf_addr.xdff_0.xinv3.mpinv_nmos
Xmos_32 xtime.xdff_buf_addr.xdff_0.z3 xtime.xdff_buf_addr.xdff_0.z2 vdd vdd surrogate_pfet_freepdk45 l=5e-08 w=5e-07 scale_vth0={M32_vth0} scale_u0={M32_u0} scale_voff={M32_voff} * xtime.xdff_buf_addr.xdff_0.xinv4.mpinv_pmos
Xmos_33 xtime.xdff_buf_addr.xdff_0.z3 xtime.xdff_buf_addr.xdff_0.z2 vss vss surrogate_nfet_freepdk45 l=5e-08 w=2.5e-07 scale_vth0={M33_vth0} scale_u0={M33_u0} scale_voff={M33_voff} * xtime.xdff_buf_addr.xdff_0.xinv4.mpinv_nmos
Xmos_34 xtime.xdff_buf_addr.xdff_0.z1 xtime.xdff_buf_addr.xdff_0.clkb xtime.xdff_buf_addr.xdff_0.z3 vdd surrogate_pfet_freepdk45 l=5e-08 w=5e-07 scale_vth0={M34_vth0} scale_u0={M34_u0} scale_voff={M34_voff} * xtime.xdff_buf_addr.xdff_0.xtg2.mtranspmos
Xmos_35 xtime.xdff_buf_addr.xdff_0.z3 clk_buf xtime.xdff_buf_addr.xdff_0.z1 vss surrogate_nfet_freepdk45 l=5e-08 w=2.5e-07 scale_vth0={M35_vth0} scale_u0={M35_u0} scale_voff={M35_voff} * xtime.xdff_buf_addr.xdff_0.xtg2.mtransnmos
Xmos_36 xtime.xdff_buf_addr.xdff_0.z4 xtime.xdff_buf_addr.xdff_0.z2 vdd vdd surrogate_pfet_freepdk45 l=5e-08 w=5e-07 scale_vth0={M36_vth0} scale_u0={M36_u0} scale_voff={M36_voff} * xtime.xdff_buf_addr.xdff_0.xinv5.mpinv_pmos
Xmos_37 xtime.xdff_buf_addr.xdff_0.z4 xtime.xdff_buf_addr.xdff_0.z2 vss vss surrogate_nfet_freepdk45 l=5e-08 w=2.5e-07 scale_vth0={M37_vth0} scale_u0={M37_u0} scale_voff={M37_voff} * xtime.xdff_buf_addr.xdff_0.xinv5.mpinv_nmos
Xmos_38 xtime.xdff_buf_addr.xdff_0.z5 xtime.xdff_buf_addr.xdff_0.clkb xtime.xdff_buf_addr.xdff_0.z4 vdd surrogate_pfet_freepdk45 l=5e-08 w=5e-07 scale_vth0={M38_vth0} scale_u0={M38_u0} scale_voff={M38_voff} * xtime.xdff_buf_addr.xdff_0.xtg3.mtranspmos
Xmos_39 xtime.xdff_buf_addr.xdff_0.z4 clk_buf xtime.xdff_buf_addr.xdff_0.z5 vss surrogate_nfet_freepdk45 l=5e-08 w=2.5e-07 scale_vth0={M39_vth0} scale_u0={M39_u0} scale_voff={M39_voff} * xtime.xdff_buf_addr.xdff_0.xtg3.mtransnmos
Xmos_40 a_dff0 xtime.xdff_buf_addr.xdff_0.z5 vdd vdd surrogate_pfet_freepdk45 l=5e-08 w=5e-07 scale_vth0={M40_vth0} scale_u0={M40_u0} scale_voff={M40_voff} * xtime.xdff_buf_addr.xdff_0.xinv6.mpinv_pmos
Xmos_41 a_dff0 xtime.xdff_buf_addr.xdff_0.z5 vss vss surrogate_nfet_freepdk45 l=5e-08 w=2.5e-07 scale_vth0={M41_vth0} scale_u0={M41_u0} scale_voff={M41_voff} * xtime.xdff_buf_addr.xdff_0.xinv6.mpinv_nmos
Xmos_42 xtime.xdff_buf_addr.xdff_0.qb a_dff0 vdd vdd surrogate_pfet_freepdk45 l=5e-08 w=5e-07 scale_vth0={M42_vth0} scale_u0={M42_u0} scale_voff={M42_voff} * xtime.xdff_buf_addr.xdff_0.xinv7.mpinv_pmos
Xmos_43 xtime.xdff_buf_addr.xdff_0.qb a_dff0 vss vss surrogate_nfet_freepdk45 l=5e-08 w=2.5e-07 scale_vth0={M43_vth0} scale_u0={M43_u0} scale_voff={M43_voff} * xtime.xdff_buf_addr.xdff_0.xinv7.mpinv_nmos
Xmos_44 xtime.xdff_buf_addr.xdff_0.z5 clk_buf xtime.xdff_buf_addr.xdff_0.qb vdd surrogate_pfet_freepdk45 l=5e-08 w=5e-07 scale_vth0={M44_vth0} scale_u0={M44_u0} scale_voff={M44_voff} * xtime.xdff_buf_addr.xdff_0.xtg4.mtranspmos
Xmos_45 xtime.xdff_buf_addr.xdff_0.qb xtime.xdff_buf_addr.xdff_0.clkb xtime.xdff_buf_addr.xdff_0.z5 vss surrogate_nfet_freepdk45 l=5e-08 w=2.5e-07 scale_vth0={M45_vth0} scale_u0={M45_u0} scale_voff={M45_voff} * xtime.xdff_buf_addr.xdff_0.xtg4.mtransnmos
Xmos_46 xtime.xclkbuf.zb1_node clk vdd vdd surrogate_pfet_freepdk45 l=5e-08 w=2.7e-07 scale_vth0={M46_vth0} scale_u0={M46_u0} scale_voff={M46_voff} * xtime.xclkbuf.xbuf_inv1.mpinv_pmos
Xmos_47 xtime.xclkbuf.zb1_node clk vss vss surrogate_nfet_freepdk45 l=5e-08 w=9e-08 scale_vth0={M47_vth0} scale_u0={M47_u0} scale_voff={M47_voff} * xtime.xclkbuf.xbuf_inv1.mpinv_nmos
Xmos_48 xtime.xclkbuf.zb2_node xtime.xclkbuf.zb1_node vdd vdd surrogate_pfet_freepdk45 l=5e-08 w=8.1e-07 scale_vth0={M48_vth0} scale_u0={M48_u0} scale_voff={M48_voff} * xtime.xclkbuf.xbuf_inv2.mpinv_pmos
Xmos_49 xtime.xclkbuf.zb2_node xtime.xclkbuf.zb1_node vss vss surrogate_nfet_freepdk45 l=5e-08 w=2.7e-07 scale_vth0={M49_vth0} scale_u0={M49_u0} scale_voff={M49_voff} * xtime.xclkbuf.xbuf_inv2.mpinv_nmos
Xmos_50 xtime.xclkbuf.zb3_node xtime.xclkbuf.zb2_node vdd vdd surrogate_pfet_freepdk45 l=5e-08 w=2.43e-06 scale_vth0={M50_vth0} scale_u0={M50_u0} scale_voff={M50_voff} * xtime.xclkbuf.xbuf_inv3.mpinv_pmos
Xmos_51 xtime.xclkbuf.zb3_node xtime.xclkbuf.zb2_node vss vss surrogate_nfet_freepdk45 l=5e-08 w=9.1e-07 scale_vth0={M51_vth0} scale_u0={M51_u0} scale_voff={M51_voff} * xtime.xclkbuf.xbuf_inv3.mpinv_nmos
Xmos_52 clk_buf xtime.xclkbuf.zb3_node vdd vdd surrogate_pfet_freepdk45 l=5e-08 w=7.29e-06 scale_vth0={M52_vth0} scale_u0={M52_u0} scale_voff={M52_voff} * xtime.xclkbuf.xbuf_inv4.mpinv_pmos
Xmos_53 clk_buf xtime.xclkbuf.zb3_node vss vss surrogate_nfet_freepdk45 l=5e-08 w=2.43e-06 scale_vth0={M53_vth0} scale_u0={M53_u0} scale_voff={M53_voff} * xtime.xclkbuf.xbuf_inv4.mpinv_nmos
Xmos_54 clk_bar clk_buf vdd vdd surrogate_pfet_freepdk45 l=5e-08 w=2.7e-07 scale_vth0={M54_vth0} scale_u0={M54_u0} scale_voff={M54_voff} * xtime.xinv_clk_bar.mpinv_pmos
Xmos_55 clk_bar clk_buf vss vss surrogate_nfet_freepdk45 l=5e-08 w=9e-08 scale_vth0={M55_vth0} scale_u0={M55_u0} scale_voff={M55_voff} * xtime.xinv_clk_bar.mpinv_nmos
Xmos_56 xtime.xdff_buf.xdff.clkb clk_buf vdd vdd surrogate_pfet_freepdk45 l=5e-08 w=5e-07 scale_vth0={M56_vth0} scale_u0={M56_u0} scale_voff={M56_voff} * xtime.xdff_buf.xdff.xinv1_clk.mpinv_pmos
Xmos_57 xtime.xdff_buf.xdff.clkb clk_buf vss vss surrogate_nfet_freepdk45 l=5e-08 w=2.5e-07 scale_vth0={M57_vth0} scale_u0={M57_u0} scale_voff={M57_voff} * xtime.xdff_buf.xdff.xinv1_clk.mpinv_nmos
Xmos_58 xtime.xdff_buf.xdff.d_b csb vdd vdd surrogate_pfet_freepdk45 l=5e-08 w=5e-07 scale_vth0={M58_vth0} scale_u0={M58_u0} scale_voff={M58_voff} * xtime.xdff_buf.xdff.xinv2_d.mpinv_pmos
Xmos_59 xtime.xdff_buf.xdff.d_b csb vss vss surrogate_nfet_freepdk45 l=5e-08 w=2.5e-07 scale_vth0={M59_vth0} scale_u0={M59_u0} scale_voff={M59_voff} * xtime.xdff_buf.xdff.xinv2_d.mpinv_nmos
Xmos_60 xtime.xdff_buf.xdff.z1 clk_buf xtime.xdff_buf.xdff.d_b vdd surrogate_pfet_freepdk45 l=5e-08 w=5e-07 scale_vth0={M60_vth0} scale_u0={M60_u0} scale_voff={M60_voff} * xtime.xdff_buf.xdff.xtg1.mtranspmos
Xmos_61 xtime.xdff_buf.xdff.d_b xtime.xdff_buf.xdff.clkb xtime.xdff_buf.xdff.z1 vss surrogate_nfet_freepdk45 l=5e-08 w=2.5e-07 scale_vth0={M61_vth0} scale_u0={M61_u0} scale_voff={M61_voff} * xtime.xdff_buf.xdff.xtg1.mtransnmos
Xmos_62 xtime.xdff_buf.xdff.z2 xtime.xdff_buf.xdff.z1 vdd vdd surrogate_pfet_freepdk45 l=5e-08 w=5e-07 scale_vth0={M62_vth0} scale_u0={M62_u0} scale_voff={M62_voff} * xtime.xdff_buf.xdff.xinv3.mpinv_pmos
Xmos_63 xtime.xdff_buf.xdff.z2 xtime.xdff_buf.xdff.z1 vss vss surrogate_nfet_freepdk45 l=5e-08 w=2.5e-07 scale_vth0={M63_vth0} scale_u0={M63_u0} scale_voff={M63_voff} * xtime.xdff_buf.xdff.xinv3.mpinv_nmos
Xmos_64 xtime.xdff_buf.xdff.z3 xtime.xdff_buf.xdff.z2 vdd vdd surrogate_pfet_freepdk45 l=5e-08 w=5e-07 scale_vth0={M64_vth0} scale_u0={M64_u0} scale_voff={M64_voff} * xtime.xdff_buf.xdff.xinv4.mpinv_pmos
Xmos_65 xtime.xdff_buf.xdff.z3 xtime.xdff_buf.xdff.z2 vss vss surrogate_nfet_freepdk45 l=5e-08 w=2.5e-07 scale_vth0={M65_vth0} scale_u0={M65_u0} scale_voff={M65_voff} * xtime.xdff_buf.xdff.xinv4.mpinv_nmos
Xmos_66 xtime.xdff_buf.xdff.z1 xtime.xdff_buf.xdff.clkb xtime.xdff_buf.xdff.z3 vdd surrogate_pfet_freepdk45 l=5e-08 w=5e-07 scale_vth0={M66_vth0} scale_u0={M66_u0} scale_voff={M66_voff} * xtime.xdff_buf.xdff.xtg2.mtranspmos
Xmos_67 xtime.xdff_buf.xdff.z3 clk_buf xtime.xdff_buf.xdff.z1 vss surrogate_nfet_freepdk45 l=5e-08 w=2.5e-07 scale_vth0={M67_vth0} scale_u0={M67_u0} scale_voff={M67_voff} * xtime.xdff_buf.xdff.xtg2.mtransnmos
Xmos_68 xtime.xdff_buf.xdff.z4 xtime.xdff_buf.xdff.z2 vdd vdd surrogate_pfet_freepdk45 l=5e-08 w=5e-07 scale_vth0={M68_vth0} scale_u0={M68_u0} scale_voff={M68_voff} * xtime.xdff_buf.xdff.xinv5.mpinv_pmos
Xmos_69 xtime.xdff_buf.xdff.z4 xtime.xdff_buf.xdff.z2 vss vss surrogate_nfet_freepdk45 l=5e-08 w=2.5e-07 scale_vth0={M69_vth0} scale_u0={M69_u0} scale_voff={M69_voff} * xtime.xdff_buf.xdff.xinv5.mpinv_nmos
Xmos_70 xtime.xdff_buf.xdff.z5 xtime.xdff_buf.xdff.clkb xtime.xdff_buf.xdff.z4 vdd surrogate_pfet_freepdk45 l=5e-08 w=5e-07 scale_vth0={M70_vth0} scale_u0={M70_u0} scale_voff={M70_voff} * xtime.xdff_buf.xdff.xtg3.mtranspmos
Xmos_71 xtime.xdff_buf.xdff.z4 clk_buf xtime.xdff_buf.xdff.z5 vss surrogate_nfet_freepdk45 l=5e-08 w=2.5e-07 scale_vth0={M71_vth0} scale_u0={M71_u0} scale_voff={M71_voff} * xtime.xdff_buf.xdff.xtg3.mtransnmos
Xmos_72 xtime.xdff_buf.qint xtime.xdff_buf.xdff.z5 vdd vdd surrogate_pfet_freepdk45 l=5e-08 w=5e-07 scale_vth0={M72_vth0} scale_u0={M72_u0} scale_voff={M72_voff} * xtime.xdff_buf.xdff.xinv6.mpinv_pmos
Xmos_73 xtime.xdff_buf.qint xtime.xdff_buf.xdff.z5 vss vss surrogate_nfet_freepdk45 l=5e-08 w=2.5e-07 scale_vth0={M73_vth0} scale_u0={M73_u0} scale_voff={M73_voff} * xtime.xdff_buf.xdff.xinv6.mpinv_nmos
Xmos_74 xtime.xdff_buf.xdff.qb xtime.xdff_buf.qint vdd vdd surrogate_pfet_freepdk45 l=5e-08 w=5e-07 scale_vth0={M74_vth0} scale_u0={M74_u0} scale_voff={M74_voff} * xtime.xdff_buf.xdff.xinv7.mpinv_pmos
Xmos_75 xtime.xdff_buf.xdff.qb xtime.xdff_buf.qint vss vss surrogate_nfet_freepdk45 l=5e-08 w=2.5e-07 scale_vth0={M75_vth0} scale_u0={M75_u0} scale_voff={M75_voff} * xtime.xdff_buf.xdff.xinv7.mpinv_nmos
Xmos_76 xtime.xdff_buf.xdff.z5 clk_buf xtime.xdff_buf.xdff.qb vdd surrogate_pfet_freepdk45 l=5e-08 w=5e-07 scale_vth0={M76_vth0} scale_u0={M76_u0} scale_voff={M76_voff} * xtime.xdff_buf.xdff.xtg4.mtranspmos
Xmos_77 xtime.xdff_buf.xdff.qb xtime.xdff_buf.xdff.clkb xtime.xdff_buf.xdff.z5 vss surrogate_nfet_freepdk45 l=5e-08 w=2.5e-07 scale_vth0={M77_vth0} scale_u0={M77_u0} scale_voff={M77_voff} * xtime.xdff_buf.xdff.xtg4.mtransnmos
Xmos_78 cs xtime.xdff_buf.qint vdd vdd surrogate_pfet_freepdk45 l=5e-08 w=5.4e-07 scale_vth0={M78_vth0} scale_u0={M78_u0} scale_voff={M78_voff} * xtime.xdff_buf.xinv1.mpinv_pmos
Xmos_79 cs xtime.xdff_buf.qint vss vss surrogate_nfet_freepdk45 l=5e-08 w=1.8e-07 scale_vth0={M79_vth0} scale_u0={M79_u0} scale_voff={M79_voff} * xtime.xdff_buf.xinv1.mpinv_nmos
Xmos_80 cs_bar cs vdd vdd surrogate_pfet_freepdk45 l=5e-08 w=1.08e-06 scale_vth0={M80_vth0} scale_u0={M80_u0} scale_voff={M80_voff} * xtime.xdff_buf.xinv2.mpinv_pmos
Xmos_81 cs_bar cs vss vss surrogate_nfet_freepdk45 l=5e-08 w=3.6e-07 scale_vth0={M81_vth0} scale_u0={M81_u0} scale_voff={M81_voff} * xtime.xdff_buf.xinv2.mpinv_nmos
Xmos_82 xtime.xdff_buf1.xdff.clkb clk_buf vdd vdd surrogate_pfet_freepdk45 l=5e-08 w=5e-07 scale_vth0={M82_vth0} scale_u0={M82_u0} scale_voff={M82_voff} * xtime.xdff_buf1.xdff.xinv1_clk.mpinv_pmos
Xmos_83 xtime.xdff_buf1.xdff.clkb clk_buf vss vss surrogate_nfet_freepdk45 l=5e-08 w=2.5e-07 scale_vth0={M83_vth0} scale_u0={M83_u0} scale_voff={M83_voff} * xtime.xdff_buf1.xdff.xinv1_clk.mpinv_nmos
Xmos_84 xtime.xdff_buf1.xdff.d_b web vdd vdd surrogate_pfet_freepdk45 l=5e-08 w=5e-07 scale_vth0={M84_vth0} scale_u0={M84_u0} scale_voff={M84_voff} * xtime.xdff_buf1.xdff.xinv2_d.mpinv_pmos
Xmos_85 xtime.xdff_buf1.xdff.d_b web vss vss surrogate_nfet_freepdk45 l=5e-08 w=2.5e-07 scale_vth0={M85_vth0} scale_u0={M85_u0} scale_voff={M85_voff} * xtime.xdff_buf1.xdff.xinv2_d.mpinv_nmos
Xmos_86 xtime.xdff_buf1.xdff.z1 clk_buf xtime.xdff_buf1.xdff.d_b vdd surrogate_pfet_freepdk45 l=5e-08 w=5e-07 scale_vth0={M86_vth0} scale_u0={M86_u0} scale_voff={M86_voff} * xtime.xdff_buf1.xdff.xtg1.mtranspmos
Xmos_87 xtime.xdff_buf1.xdff.d_b xtime.xdff_buf1.xdff.clkb xtime.xdff_buf1.xdff.z1 vss surrogate_nfet_freepdk45 l=5e-08 w=2.5e-07 scale_vth0={M87_vth0} scale_u0={M87_u0} scale_voff={M87_voff} * xtime.xdff_buf1.xdff.xtg1.mtransnmos
Xmos_88 xtime.xdff_buf1.xdff.z2 xtime.xdff_buf1.xdff.z1 vdd vdd surrogate_pfet_freepdk45 l=5e-08 w=5e-07 scale_vth0={M88_vth0} scale_u0={M88_u0} scale_voff={M88_voff} * xtime.xdff_buf1.xdff.xinv3.mpinv_pmos
Xmos_89 xtime.xdff_buf1.xdff.z2 xtime.xdff_buf1.xdff.z1 vss vss surrogate_nfet_freepdk45 l=5e-08 w=2.5e-07 scale_vth0={M89_vth0} scale_u0={M89_u0} scale_voff={M89_voff} * xtime.xdff_buf1.xdff.xinv3.mpinv_nmos
Xmos_90 xtime.xdff_buf1.xdff.z3 xtime.xdff_buf1.xdff.z2 vdd vdd surrogate_pfet_freepdk45 l=5e-08 w=5e-07 scale_vth0={M90_vth0} scale_u0={M90_u0} scale_voff={M90_voff} * xtime.xdff_buf1.xdff.xinv4.mpinv_pmos
Xmos_91 xtime.xdff_buf1.xdff.z3 xtime.xdff_buf1.xdff.z2 vss vss surrogate_nfet_freepdk45 l=5e-08 w=2.5e-07 scale_vth0={M91_vth0} scale_u0={M91_u0} scale_voff={M91_voff} * xtime.xdff_buf1.xdff.xinv4.mpinv_nmos
Xmos_92 xtime.xdff_buf1.xdff.z1 xtime.xdff_buf1.xdff.clkb xtime.xdff_buf1.xdff.z3 vdd surrogate_pfet_freepdk45 l=5e-08 w=5e-07 scale_vth0={M92_vth0} scale_u0={M92_u0} scale_voff={M92_voff} * xtime.xdff_buf1.xdff.xtg2.mtranspmos
Xmos_93 xtime.xdff_buf1.xdff.z3 clk_buf xtime.xdff_buf1.xdff.z1 vss surrogate_nfet_freepdk45 l=5e-08 w=2.5e-07 scale_vth0={M93_vth0} scale_u0={M93_u0} scale_voff={M93_voff} * xtime.xdff_buf1.xdff.xtg2.mtransnmos
Xmos_94 xtime.xdff_buf1.xdff.z4 xtime.xdff_buf1.xdff.z2 vdd vdd surrogate_pfet_freepdk45 l=5e-08 w=5e-07 scale_vth0={M94_vth0} scale_u0={M94_u0} scale_voff={M94_voff} * xtime.xdff_buf1.xdff.xinv5.mpinv_pmos
Xmos_95 xtime.xdff_buf1.xdff.z4 xtime.xdff_buf1.xdff.z2 vss vss surrogate_nfet_freepdk45 l=5e-08 w=2.5e-07 scale_vth0={M95_vth0} scale_u0={M95_u0} scale_voff={M95_voff} * xtime.xdff_buf1.xdff.xinv5.mpinv_nmos
Xmos_96 xtime.xdff_buf1.xdff.z5 xtime.xdff_buf1.xdff.clkb xtime.xdff_buf1.xdff.z4 vdd surrogate_pfet_freepdk45 l=5e-08 w=5e-07 scale_vth0={M96_vth0} scale_u0={M96_u0} scale_voff={M96_voff} * xtime.xdff_buf1.xdff.xtg3.mtranspmos
Xmos_97 xtime.xdff_buf1.xdff.z4 clk_buf xtime.xdff_buf1.xdff.z5 vss surrogate_nfet_freepdk45 l=5e-08 w=2.5e-07 scale_vth0={M97_vth0} scale_u0={M97_u0} scale_voff={M97_voff} * xtime.xdff_buf1.xdff.xtg3.mtransnmos
Xmos_98 xtime.xdff_buf1.qint xtime.xdff_buf1.xdff.z5 vdd vdd surrogate_pfet_freepdk45 l=5e-08 w=5e-07 scale_vth0={M98_vth0} scale_u0={M98_u0} scale_voff={M98_voff} * xtime.xdff_buf1.xdff.xinv6.mpinv_pmos
Xmos_99 xtime.xdff_buf1.qint xtime.xdff_buf1.xdff.z5 vss vss surrogate_nfet_freepdk45 l=5e-08 w=2.5e-07 scale_vth0={M99_vth0} scale_u0={M99_u0} scale_voff={M99_voff} * xtime.xdff_buf1.xdff.xinv6.mpinv_nmos
Xmos_100 xtime.xdff_buf1.xdff.qb xtime.xdff_buf1.qint vdd vdd surrogate_pfet_freepdk45 l=5e-08 w=5e-07 scale_vth0={M100_vth0} scale_u0={M100_u0} scale_voff={M100_voff} * xtime.xdff_buf1.xdff.xinv7.mpinv_pmos
Xmos_101 xtime.xdff_buf1.xdff.qb xtime.xdff_buf1.qint vss vss surrogate_nfet_freepdk45 l=5e-08 w=2.5e-07 scale_vth0={M101_vth0} scale_u0={M101_u0} scale_voff={M101_voff} * xtime.xdff_buf1.xdff.xinv7.mpinv_nmos
Xmos_102 xtime.xdff_buf1.xdff.z5 clk_buf xtime.xdff_buf1.xdff.qb vdd surrogate_pfet_freepdk45 l=5e-08 w=5e-07 scale_vth0={M102_vth0} scale_u0={M102_u0} scale_voff={M102_voff} * xtime.xdff_buf1.xdff.xtg4.mtranspmos
Xmos_103 xtime.xdff_buf1.xdff.qb xtime.xdff_buf1.xdff.clkb xtime.xdff_buf1.xdff.z5 vss surrogate_nfet_freepdk45 l=5e-08 w=2.5e-07 scale_vth0={M103_vth0} scale_u0={M103_u0} scale_voff={M103_voff} * xtime.xdff_buf1.xdff.xtg4.mtransnmos
Xmos_104 we xtime.xdff_buf1.qint vdd vdd surrogate_pfet_freepdk45 l=5e-08 w=5.4e-07 scale_vth0={M104_vth0} scale_u0={M104_u0} scale_voff={M104_voff} * xtime.xdff_buf1.xinv1.mpinv_pmos
Xmos_105 we xtime.xdff_buf1.qint vss vss surrogate_nfet_freepdk45 l=5e-08 w=1.8e-07 scale_vth0={M105_vth0} scale_u0={M105_u0} scale_voff={M105_voff} * xtime.xdff_buf1.xinv1.mpinv_nmos
Xmos_106 we_bar we vdd vdd surrogate_pfet_freepdk45 l=5e-08 w=1.08e-06 scale_vth0={M106_vth0} scale_u0={M106_u0} scale_voff={M106_voff} * xtime.xdff_buf1.xinv2.mpinv_pmos
Xmos_107 we_bar we vss vss surrogate_nfet_freepdk45 l=5e-08 w=3.6e-07 scale_vth0={M107_vth0} scale_u0={M107_u0} scale_voff={M107_voff} * xtime.xdff_buf1.xinv2.mpinv_nmos
Xmos_108 xtime.xand2_gated_clk_bar.zb_int cs vdd vdd surrogate_pfet_freepdk45 l=5e-08 w=2.7e-07 scale_vth0={M108_vth0} scale_u0={M108_u0} scale_voff={M108_voff} * xtime.xand2_gated_clk_bar.xpnand3.mpnand2_pmos1
Xmos_109 xtime.xand2_gated_clk_bar.zb_int clk_bar vdd vdd surrogate_pfet_freepdk45 l=5e-08 w=2.7e-07 scale_vth0={M109_vth0} scale_u0={M109_u0} scale_voff={M109_voff} * xtime.xand2_gated_clk_bar.xpnand3.mpnand2_pmos2
Xmos_110 xtime.xand2_gated_clk_bar.zb_int clk_bar xtime.xand2_gated_clk_bar.xpnand3.net1 vss surrogate_nfet_freepdk45 l=5e-08 w=1.8e-07 scale_vth0={M110_vth0} scale_u0={M110_u0} scale_voff={M110_voff} * xtime.xand2_gated_clk_bar.xpnand3.mpnand2_nmos1
Xmos_111 xtime.xand2_gated_clk_bar.xpnand3.net1 cs vss vss surrogate_nfet_freepdk45 l=5e-08 w=1.8e-07 scale_vth0={M111_vth0} scale_u0={M111_u0} scale_voff={M111_voff} * xtime.xand2_gated_clk_bar.xpnand3.mpnand2_nmos2
Xmos_112 gated_clk_bar xtime.xand2_gated_clk_bar.zb_int vdd vdd surrogate_pfet_freepdk45 l=5e-08 w=1.62e-06 scale_vth0={M112_vth0} scale_u0={M112_u0} scale_voff={M112_voff} * xtime.xand2_gated_clk_bar.xpinv.mpinv_pmos
Xmos_113 gated_clk_bar xtime.xand2_gated_clk_bar.zb_int vss vss surrogate_nfet_freepdk45 l=5e-08 w=5.4e-07 scale_vth0={M113_vth0} scale_u0={M113_u0} scale_voff={M113_voff} * xtime.xand2_gated_clk_bar.xpinv.mpinv_nmos
Xmos_114 xtime.xand2_gated_clk_buf.zb_int cs vdd vdd surrogate_pfet_freepdk45 l=5e-08 w=2.7e-07 scale_vth0={M114_vth0} scale_u0={M114_u0} scale_voff={M114_voff} * xtime.xand2_gated_clk_buf.xpnand3.mpnand2_pmos1
Xmos_115 xtime.xand2_gated_clk_buf.zb_int clk_buf vdd vdd surrogate_pfet_freepdk45 l=5e-08 w=2.7e-07 scale_vth0={M115_vth0} scale_u0={M115_u0} scale_voff={M115_voff} * xtime.xand2_gated_clk_buf.xpnand3.mpnand2_pmos2
Xmos_116 xtime.xand2_gated_clk_buf.zb_int clk_buf xtime.xand2_gated_clk_buf.xpnand3.net1 vss surrogate_nfet_freepdk45 l=5e-08 w=1.8e-07 scale_vth0={M116_vth0} scale_u0={M116_u0} scale_voff={M116_voff} * xtime.xand2_gated_clk_buf.xpnand3.mpnand2_nmos1
Xmos_117 xtime.xand2_gated_clk_buf.xpnand3.net1 cs vss vss surrogate_nfet_freepdk45 l=5e-08 w=1.8e-07 scale_vth0={M117_vth0} scale_u0={M117_u0} scale_voff={M117_voff} * xtime.xand2_gated_clk_buf.xpnand3.mpnand2_nmos2
Xmos_118 gated_clk_buf xtime.xand2_gated_clk_buf.zb_int vdd vdd surrogate_pfet_freepdk45 l=5e-08 w=1.62e-06 scale_vth0={M118_vth0} scale_u0={M118_u0} scale_voff={M118_voff} * xtime.xand2_gated_clk_buf.xpinv.mpinv_pmos
Xmos_119 gated_clk_buf xtime.xand2_gated_clk_buf.zb_int vss vss surrogate_nfet_freepdk45 l=5e-08 w=5.4e-07 scale_vth0={M119_vth0} scale_u0={M119_u0} scale_voff={M119_voff} * xtime.xand2_gated_clk_buf.xpinv.mpinv_nmos
Xmos_120 xtime.xwl_en.zb1_node gated_clk_bar vdd vdd surrogate_pfet_freepdk45 l=5e-08 w=2.7e-07 scale_vth0={M120_vth0} scale_u0={M120_u0} scale_voff={M120_voff} * xtime.xwl_en.xbuf_inv1.mpinv_pmos
Xmos_121 xtime.xwl_en.zb1_node gated_clk_bar vss vss surrogate_nfet_freepdk45 l=5e-08 w=9e-08 scale_vth0={M121_vth0} scale_u0={M121_u0} scale_voff={M121_voff} * xtime.xwl_en.xbuf_inv1.mpinv_nmos
Xmos_122 wl_en xtime.xwl_en.zb1_node vdd vdd surrogate_pfet_freepdk45 l=5e-08 w=1.35e-06 scale_vth0={M122_vth0} scale_u0={M122_u0} scale_voff={M122_voff} * xtime.xwl_en.xbuf_inv2.mpinv_pmos
Xmos_123 wl_en xtime.xwl_en.zb1_node vss vss surrogate_nfet_freepdk45 l=5e-08 w=4.5e-07 scale_vth0={M123_vth0} scale_u0={M123_u0} scale_voff={M123_voff} * xtime.xwl_en.xbuf_inv2.mpinv_nmos
Xmos_124 xtime.wl_en_bar wl_en vdd vdd surrogate_pfet_freepdk45 l=5e-08 w=2.7e-07 scale_vth0={M124_vth0} scale_u0={M124_u0} scale_voff={M124_voff} * xtime.xinv_wl_en_bar.mpinv_pmos
Xmos_125 xtime.wl_en_bar wl_en vss vss surrogate_nfet_freepdk45 l=5e-08 w=9e-08 scale_vth0={M125_vth0} scale_u0={M125_u0} scale_voff={M125_voff} * xtime.xinv_wl_en_bar.mpinv_nmos
Xmos_126 xtime.xdelaychain.dout_1 rbl vdd vdd surrogate_pfet_freepdk45 l=5e-08 w=2.7e-07 scale_vth0={M126_vth0} scale_u0={M126_u0} scale_voff={M126_voff} * xtime.xdelaychain.xdinv0.mpinv_pmos
Xmos_127 xtime.xdelaychain.dout_1 rbl vss vss surrogate_nfet_freepdk45 l=5e-08 w=9e-08 scale_vth0={M127_vth0} scale_u0={M127_u0} scale_voff={M127_voff} * xtime.xdelaychain.xdinv0.mpinv_nmos
Xmos_128 xtime.xdelaychain.n_0_0 xtime.xdelaychain.dout_1 vdd vdd surrogate_pfet_freepdk45 l=5e-08 w=2.7e-07 scale_vth0={M128_vth0} scale_u0={M128_u0} scale_voff={M128_voff} * xtime.xdelaychain.xdload_0_0.mpinv_pmos
Xmos_129 xtime.xdelaychain.n_0_0 xtime.xdelaychain.dout_1 vss vss surrogate_nfet_freepdk45 l=5e-08 w=9e-08 scale_vth0={M129_vth0} scale_u0={M129_u0} scale_voff={M129_voff} * xtime.xdelaychain.xdload_0_0.mpinv_nmos
Xmos_130 xtime.xdelaychain.n_0_1 xtime.xdelaychain.dout_1 vdd vdd surrogate_pfet_freepdk45 l=5e-08 w=2.7e-07 scale_vth0={M130_vth0} scale_u0={M130_u0} scale_voff={M130_voff} * xtime.xdelaychain.xdload_0_1.mpinv_pmos
Xmos_131 xtime.xdelaychain.n_0_1 xtime.xdelaychain.dout_1 vss vss surrogate_nfet_freepdk45 l=5e-08 w=9e-08 scale_vth0={M131_vth0} scale_u0={M131_u0} scale_voff={M131_voff} * xtime.xdelaychain.xdload_0_1.mpinv_nmos
Xmos_132 xtime.xdelaychain.n_0_2 xtime.xdelaychain.dout_1 vdd vdd surrogate_pfet_freepdk45 l=5e-08 w=2.7e-07 scale_vth0={M132_vth0} scale_u0={M132_u0} scale_voff={M132_voff} * xtime.xdelaychain.xdload_0_2.mpinv_pmos
Xmos_133 xtime.xdelaychain.n_0_2 xtime.xdelaychain.dout_1 vss vss surrogate_nfet_freepdk45 l=5e-08 w=9e-08 scale_vth0={M133_vth0} scale_u0={M133_u0} scale_voff={M133_voff} * xtime.xdelaychain.xdload_0_2.mpinv_nmos
Xmos_134 xtime.xdelaychain.n_0_3 xtime.xdelaychain.dout_1 vdd vdd surrogate_pfet_freepdk45 l=5e-08 w=2.7e-07 scale_vth0={M134_vth0} scale_u0={M134_u0} scale_voff={M134_voff} * xtime.xdelaychain.xdload_0_3.mpinv_pmos
Xmos_135 xtime.xdelaychain.n_0_3 xtime.xdelaychain.dout_1 vss vss surrogate_nfet_freepdk45 l=5e-08 w=9e-08 scale_vth0={M135_vth0} scale_u0={M135_u0} scale_voff={M135_voff} * xtime.xdelaychain.xdload_0_3.mpinv_nmos
Xmos_136 xtime.xdelaychain.dout_2 xtime.xdelaychain.dout_1 vdd vdd surrogate_pfet_freepdk45 l=5e-08 w=2.7e-07 scale_vth0={M136_vth0} scale_u0={M136_u0} scale_voff={M136_voff} * xtime.xdelaychain.xdinv1.mpinv_pmos
Xmos_137 xtime.xdelaychain.dout_2 xtime.xdelaychain.dout_1 vss vss surrogate_nfet_freepdk45 l=5e-08 w=9e-08 scale_vth0={M137_vth0} scale_u0={M137_u0} scale_voff={M137_voff} * xtime.xdelaychain.xdinv1.mpinv_nmos
Xmos_138 xtime.xdelaychain.n_1_0 xtime.xdelaychain.dout_2 vdd vdd surrogate_pfet_freepdk45 l=5e-08 w=2.7e-07 scale_vth0={M138_vth0} scale_u0={M138_u0} scale_voff={M138_voff} * xtime.xdelaychain.xdload_1_0.mpinv_pmos
Xmos_139 xtime.xdelaychain.n_1_0 xtime.xdelaychain.dout_2 vss vss surrogate_nfet_freepdk45 l=5e-08 w=9e-08 scale_vth0={M139_vth0} scale_u0={M139_u0} scale_voff={M139_voff} * xtime.xdelaychain.xdload_1_0.mpinv_nmos
Xmos_140 xtime.xdelaychain.n_1_1 xtime.xdelaychain.dout_2 vdd vdd surrogate_pfet_freepdk45 l=5e-08 w=2.7e-07 scale_vth0={M140_vth0} scale_u0={M140_u0} scale_voff={M140_voff} * xtime.xdelaychain.xdload_1_1.mpinv_pmos
Xmos_141 xtime.xdelaychain.n_1_1 xtime.xdelaychain.dout_2 vss vss surrogate_nfet_freepdk45 l=5e-08 w=9e-08 scale_vth0={M141_vth0} scale_u0={M141_u0} scale_voff={M141_voff} * xtime.xdelaychain.xdload_1_1.mpinv_nmos
Xmos_142 xtime.xdelaychain.n_1_2 xtime.xdelaychain.dout_2 vdd vdd surrogate_pfet_freepdk45 l=5e-08 w=2.7e-07 scale_vth0={M142_vth0} scale_u0={M142_u0} scale_voff={M142_voff} * xtime.xdelaychain.xdload_1_2.mpinv_pmos
Xmos_143 xtime.xdelaychain.n_1_2 xtime.xdelaychain.dout_2 vss vss surrogate_nfet_freepdk45 l=5e-08 w=9e-08 scale_vth0={M143_vth0} scale_u0={M143_u0} scale_voff={M143_voff} * xtime.xdelaychain.xdload_1_2.mpinv_nmos
Xmos_144 xtime.xdelaychain.n_1_3 xtime.xdelaychain.dout_2 vdd vdd surrogate_pfet_freepdk45 l=5e-08 w=2.7e-07 scale_vth0={M144_vth0} scale_u0={M144_u0} scale_voff={M144_voff} * xtime.xdelaychain.xdload_1_3.mpinv_pmos
Xmos_145 xtime.xdelaychain.n_1_3 xtime.xdelaychain.dout_2 vss vss surrogate_nfet_freepdk45 l=5e-08 w=9e-08 scale_vth0={M145_vth0} scale_u0={M145_u0} scale_voff={M145_voff} * xtime.xdelaychain.xdload_1_3.mpinv_nmos
Xmos_146 xtime.xdelaychain.dout_3 xtime.xdelaychain.dout_2 vdd vdd surrogate_pfet_freepdk45 l=5e-08 w=2.7e-07 scale_vth0={M146_vth0} scale_u0={M146_u0} scale_voff={M146_voff} * xtime.xdelaychain.xdinv2.mpinv_pmos
Xmos_147 xtime.xdelaychain.dout_3 xtime.xdelaychain.dout_2 vss vss surrogate_nfet_freepdk45 l=5e-08 w=9e-08 scale_vth0={M147_vth0} scale_u0={M147_u0} scale_voff={M147_voff} * xtime.xdelaychain.xdinv2.mpinv_nmos
Xmos_148 xtime.xdelaychain.n_2_0 xtime.xdelaychain.dout_3 vdd vdd surrogate_pfet_freepdk45 l=5e-08 w=2.7e-07 scale_vth0={M148_vth0} scale_u0={M148_u0} scale_voff={M148_voff} * xtime.xdelaychain.xdload_2_0.mpinv_pmos
Xmos_149 xtime.xdelaychain.n_2_0 xtime.xdelaychain.dout_3 vss vss surrogate_nfet_freepdk45 l=5e-08 w=9e-08 scale_vth0={M149_vth0} scale_u0={M149_u0} scale_voff={M149_voff} * xtime.xdelaychain.xdload_2_0.mpinv_nmos
Xmos_150 xtime.xdelaychain.n_2_1 xtime.xdelaychain.dout_3 vdd vdd surrogate_pfet_freepdk45 l=5e-08 w=2.7e-07 scale_vth0={M150_vth0} scale_u0={M150_u0} scale_voff={M150_voff} * xtime.xdelaychain.xdload_2_1.mpinv_pmos
Xmos_151 xtime.xdelaychain.n_2_1 xtime.xdelaychain.dout_3 vss vss surrogate_nfet_freepdk45 l=5e-08 w=9e-08 scale_vth0={M151_vth0} scale_u0={M151_u0} scale_voff={M151_voff} * xtime.xdelaychain.xdload_2_1.mpinv_nmos
Xmos_152 xtime.xdelaychain.n_2_2 xtime.xdelaychain.dout_3 vdd vdd surrogate_pfet_freepdk45 l=5e-08 w=2.7e-07 scale_vth0={M152_vth0} scale_u0={M152_u0} scale_voff={M152_voff} * xtime.xdelaychain.xdload_2_2.mpinv_pmos
Xmos_153 xtime.xdelaychain.n_2_2 xtime.xdelaychain.dout_3 vss vss surrogate_nfet_freepdk45 l=5e-08 w=9e-08 scale_vth0={M153_vth0} scale_u0={M153_u0} scale_voff={M153_voff} * xtime.xdelaychain.xdload_2_2.mpinv_nmos
Xmos_154 xtime.xdelaychain.n_2_3 xtime.xdelaychain.dout_3 vdd vdd surrogate_pfet_freepdk45 l=5e-08 w=2.7e-07 scale_vth0={M154_vth0} scale_u0={M154_u0} scale_voff={M154_voff} * xtime.xdelaychain.xdload_2_3.mpinv_pmos
Xmos_155 xtime.xdelaychain.n_2_3 xtime.xdelaychain.dout_3 vss vss surrogate_nfet_freepdk45 l=5e-08 w=9e-08 scale_vth0={M155_vth0} scale_u0={M155_u0} scale_voff={M155_voff} * xtime.xdelaychain.xdload_2_3.mpinv_nmos
Xmos_156 xtime.xdelaychain.dout_4 xtime.xdelaychain.dout_3 vdd vdd surrogate_pfet_freepdk45 l=5e-08 w=2.7e-07 scale_vth0={M156_vth0} scale_u0={M156_u0} scale_voff={M156_voff} * xtime.xdelaychain.xdinv3.mpinv_pmos
Xmos_157 xtime.xdelaychain.dout_4 xtime.xdelaychain.dout_3 vss vss surrogate_nfet_freepdk45 l=5e-08 w=9e-08 scale_vth0={M157_vth0} scale_u0={M157_u0} scale_voff={M157_voff} * xtime.xdelaychain.xdinv3.mpinv_nmos
Xmos_158 xtime.xdelaychain.n_3_0 xtime.xdelaychain.dout_4 vdd vdd surrogate_pfet_freepdk45 l=5e-08 w=2.7e-07 scale_vth0={M158_vth0} scale_u0={M158_u0} scale_voff={M158_voff} * xtime.xdelaychain.xdload_3_0.mpinv_pmos
Xmos_159 xtime.xdelaychain.n_3_0 xtime.xdelaychain.dout_4 vss vss surrogate_nfet_freepdk45 l=5e-08 w=9e-08 scale_vth0={M159_vth0} scale_u0={M159_u0} scale_voff={M159_voff} * xtime.xdelaychain.xdload_3_0.mpinv_nmos
Xmos_160 xtime.xdelaychain.n_3_1 xtime.xdelaychain.dout_4 vdd vdd surrogate_pfet_freepdk45 l=5e-08 w=2.7e-07 scale_vth0={M160_vth0} scale_u0={M160_u0} scale_voff={M160_voff} * xtime.xdelaychain.xdload_3_1.mpinv_pmos
Xmos_161 xtime.xdelaychain.n_3_1 xtime.xdelaychain.dout_4 vss vss surrogate_nfet_freepdk45 l=5e-08 w=9e-08 scale_vth0={M161_vth0} scale_u0={M161_u0} scale_voff={M161_voff} * xtime.xdelaychain.xdload_3_1.mpinv_nmos
Xmos_162 xtime.xdelaychain.n_3_2 xtime.xdelaychain.dout_4 vdd vdd surrogate_pfet_freepdk45 l=5e-08 w=2.7e-07 scale_vth0={M162_vth0} scale_u0={M162_u0} scale_voff={M162_voff} * xtime.xdelaychain.xdload_3_2.mpinv_pmos
Xmos_163 xtime.xdelaychain.n_3_2 xtime.xdelaychain.dout_4 vss vss surrogate_nfet_freepdk45 l=5e-08 w=9e-08 scale_vth0={M163_vth0} scale_u0={M163_u0} scale_voff={M163_voff} * xtime.xdelaychain.xdload_3_2.mpinv_nmos
Xmos_164 xtime.xdelaychain.n_3_3 xtime.xdelaychain.dout_4 vdd vdd surrogate_pfet_freepdk45 l=5e-08 w=2.7e-07 scale_vth0={M164_vth0} scale_u0={M164_u0} scale_voff={M164_voff} * xtime.xdelaychain.xdload_3_3.mpinv_pmos
Xmos_165 xtime.xdelaychain.n_3_3 xtime.xdelaychain.dout_4 vss vss surrogate_nfet_freepdk45 l=5e-08 w=9e-08 scale_vth0={M165_vth0} scale_u0={M165_u0} scale_voff={M165_voff} * xtime.xdelaychain.xdload_3_3.mpinv_nmos
Xmos_166 xtime.xdelaychain.dout_5 xtime.xdelaychain.dout_4 vdd vdd surrogate_pfet_freepdk45 l=5e-08 w=2.7e-07 scale_vth0={M166_vth0} scale_u0={M166_u0} scale_voff={M166_voff} * xtime.xdelaychain.xdinv4.mpinv_pmos
Xmos_167 xtime.xdelaychain.dout_5 xtime.xdelaychain.dout_4 vss vss surrogate_nfet_freepdk45 l=5e-08 w=9e-08 scale_vth0={M167_vth0} scale_u0={M167_u0} scale_voff={M167_voff} * xtime.xdelaychain.xdinv4.mpinv_nmos
Xmos_168 xtime.xdelaychain.n_4_0 xtime.xdelaychain.dout_5 vdd vdd surrogate_pfet_freepdk45 l=5e-08 w=2.7e-07 scale_vth0={M168_vth0} scale_u0={M168_u0} scale_voff={M168_voff} * xtime.xdelaychain.xdload_4_0.mpinv_pmos
Xmos_169 xtime.xdelaychain.n_4_0 xtime.xdelaychain.dout_5 vss vss surrogate_nfet_freepdk45 l=5e-08 w=9e-08 scale_vth0={M169_vth0} scale_u0={M169_u0} scale_voff={M169_voff} * xtime.xdelaychain.xdload_4_0.mpinv_nmos
Xmos_170 xtime.xdelaychain.n_4_1 xtime.xdelaychain.dout_5 vdd vdd surrogate_pfet_freepdk45 l=5e-08 w=2.7e-07 scale_vth0={M170_vth0} scale_u0={M170_u0} scale_voff={M170_voff} * xtime.xdelaychain.xdload_4_1.mpinv_pmos
Xmos_171 xtime.xdelaychain.n_4_1 xtime.xdelaychain.dout_5 vss vss surrogate_nfet_freepdk45 l=5e-08 w=9e-08 scale_vth0={M171_vth0} scale_u0={M171_u0} scale_voff={M171_voff} * xtime.xdelaychain.xdload_4_1.mpinv_nmos
Xmos_172 xtime.xdelaychain.n_4_2 xtime.xdelaychain.dout_5 vdd vdd surrogate_pfet_freepdk45 l=5e-08 w=2.7e-07 scale_vth0={M172_vth0} scale_u0={M172_u0} scale_voff={M172_voff} * xtime.xdelaychain.xdload_4_2.mpinv_pmos
Xmos_173 xtime.xdelaychain.n_4_2 xtime.xdelaychain.dout_5 vss vss surrogate_nfet_freepdk45 l=5e-08 w=9e-08 scale_vth0={M173_vth0} scale_u0={M173_u0} scale_voff={M173_voff} * xtime.xdelaychain.xdload_4_2.mpinv_nmos
Xmos_174 xtime.xdelaychain.n_4_3 xtime.xdelaychain.dout_5 vdd vdd surrogate_pfet_freepdk45 l=5e-08 w=2.7e-07 scale_vth0={M174_vth0} scale_u0={M174_u0} scale_voff={M174_voff} * xtime.xdelaychain.xdload_4_3.mpinv_pmos
Xmos_175 xtime.xdelaychain.n_4_3 xtime.xdelaychain.dout_5 vss vss surrogate_nfet_freepdk45 l=5e-08 w=9e-08 scale_vth0={M175_vth0} scale_u0={M175_u0} scale_voff={M175_voff} * xtime.xdelaychain.xdload_4_3.mpinv_nmos
Xmos_176 xtime.xdelaychain.dout_6 xtime.xdelaychain.dout_5 vdd vdd surrogate_pfet_freepdk45 l=5e-08 w=2.7e-07 scale_vth0={M176_vth0} scale_u0={M176_u0} scale_voff={M176_voff} * xtime.xdelaychain.xdinv5.mpinv_pmos
Xmos_177 xtime.xdelaychain.dout_6 xtime.xdelaychain.dout_5 vss vss surrogate_nfet_freepdk45 l=5e-08 w=9e-08 scale_vth0={M177_vth0} scale_u0={M177_u0} scale_voff={M177_voff} * xtime.xdelaychain.xdinv5.mpinv_nmos
Xmos_178 xtime.xdelaychain.n_5_0 xtime.xdelaychain.dout_6 vdd vdd surrogate_pfet_freepdk45 l=5e-08 w=2.7e-07 scale_vth0={M178_vth0} scale_u0={M178_u0} scale_voff={M178_voff} * xtime.xdelaychain.xdload_5_0.mpinv_pmos
Xmos_179 xtime.xdelaychain.n_5_0 xtime.xdelaychain.dout_6 vss vss surrogate_nfet_freepdk45 l=5e-08 w=9e-08 scale_vth0={M179_vth0} scale_u0={M179_u0} scale_voff={M179_voff} * xtime.xdelaychain.xdload_5_0.mpinv_nmos
Xmos_180 xtime.xdelaychain.n_5_1 xtime.xdelaychain.dout_6 vdd vdd surrogate_pfet_freepdk45 l=5e-08 w=2.7e-07 scale_vth0={M180_vth0} scale_u0={M180_u0} scale_voff={M180_voff} * xtime.xdelaychain.xdload_5_1.mpinv_pmos
Xmos_181 xtime.xdelaychain.n_5_1 xtime.xdelaychain.dout_6 vss vss surrogate_nfet_freepdk45 l=5e-08 w=9e-08 scale_vth0={M181_vth0} scale_u0={M181_u0} scale_voff={M181_voff} * xtime.xdelaychain.xdload_5_1.mpinv_nmos
Xmos_182 xtime.xdelaychain.n_5_2 xtime.xdelaychain.dout_6 vdd vdd surrogate_pfet_freepdk45 l=5e-08 w=2.7e-07 scale_vth0={M182_vth0} scale_u0={M182_u0} scale_voff={M182_voff} * xtime.xdelaychain.xdload_5_2.mpinv_pmos
Xmos_183 xtime.xdelaychain.n_5_2 xtime.xdelaychain.dout_6 vss vss surrogate_nfet_freepdk45 l=5e-08 w=9e-08 scale_vth0={M183_vth0} scale_u0={M183_u0} scale_voff={M183_voff} * xtime.xdelaychain.xdload_5_2.mpinv_nmos
Xmos_184 xtime.xdelaychain.n_5_3 xtime.xdelaychain.dout_6 vdd vdd surrogate_pfet_freepdk45 l=5e-08 w=2.7e-07 scale_vth0={M184_vth0} scale_u0={M184_u0} scale_voff={M184_voff} * xtime.xdelaychain.xdload_5_3.mpinv_pmos
Xmos_185 xtime.xdelaychain.n_5_3 xtime.xdelaychain.dout_6 vss vss surrogate_nfet_freepdk45 l=5e-08 w=9e-08 scale_vth0={M185_vth0} scale_u0={M185_u0} scale_voff={M185_voff} * xtime.xdelaychain.xdload_5_3.mpinv_nmos
Xmos_186 xtime.xdelaychain.dout_7 xtime.xdelaychain.dout_6 vdd vdd surrogate_pfet_freepdk45 l=5e-08 w=2.7e-07 scale_vth0={M186_vth0} scale_u0={M186_u0} scale_voff={M186_voff} * xtime.xdelaychain.xdinv6.mpinv_pmos
Xmos_187 xtime.xdelaychain.dout_7 xtime.xdelaychain.dout_6 vss vss surrogate_nfet_freepdk45 l=5e-08 w=9e-08 scale_vth0={M187_vth0} scale_u0={M187_u0} scale_voff={M187_voff} * xtime.xdelaychain.xdinv6.mpinv_nmos
Xmos_188 xtime.xdelaychain.n_6_0 xtime.xdelaychain.dout_7 vdd vdd surrogate_pfet_freepdk45 l=5e-08 w=2.7e-07 scale_vth0={M188_vth0} scale_u0={M188_u0} scale_voff={M188_voff} * xtime.xdelaychain.xdload_6_0.mpinv_pmos
Xmos_189 xtime.xdelaychain.n_6_0 xtime.xdelaychain.dout_7 vss vss surrogate_nfet_freepdk45 l=5e-08 w=9e-08 scale_vth0={M189_vth0} scale_u0={M189_u0} scale_voff={M189_voff} * xtime.xdelaychain.xdload_6_0.mpinv_nmos
Xmos_190 xtime.xdelaychain.n_6_1 xtime.xdelaychain.dout_7 vdd vdd surrogate_pfet_freepdk45 l=5e-08 w=2.7e-07 scale_vth0={M190_vth0} scale_u0={M190_u0} scale_voff={M190_voff} * xtime.xdelaychain.xdload_6_1.mpinv_pmos
Xmos_191 xtime.xdelaychain.n_6_1 xtime.xdelaychain.dout_7 vss vss surrogate_nfet_freepdk45 l=5e-08 w=9e-08 scale_vth0={M191_vth0} scale_u0={M191_u0} scale_voff={M191_voff} * xtime.xdelaychain.xdload_6_1.mpinv_nmos
Xmos_192 xtime.xdelaychain.n_6_2 xtime.xdelaychain.dout_7 vdd vdd surrogate_pfet_freepdk45 l=5e-08 w=2.7e-07 scale_vth0={M192_vth0} scale_u0={M192_u0} scale_voff={M192_voff} * xtime.xdelaychain.xdload_6_2.mpinv_pmos
Xmos_193 xtime.xdelaychain.n_6_2 xtime.xdelaychain.dout_7 vss vss surrogate_nfet_freepdk45 l=5e-08 w=9e-08 scale_vth0={M193_vth0} scale_u0={M193_u0} scale_voff={M193_voff} * xtime.xdelaychain.xdload_6_2.mpinv_nmos
Xmos_194 xtime.xdelaychain.n_6_3 xtime.xdelaychain.dout_7 vdd vdd surrogate_pfet_freepdk45 l=5e-08 w=2.7e-07 scale_vth0={M194_vth0} scale_u0={M194_u0} scale_voff={M194_voff} * xtime.xdelaychain.xdload_6_3.mpinv_pmos
Xmos_195 xtime.xdelaychain.n_6_3 xtime.xdelaychain.dout_7 vss vss surrogate_nfet_freepdk45 l=5e-08 w=9e-08 scale_vth0={M195_vth0} scale_u0={M195_u0} scale_voff={M195_voff} * xtime.xdelaychain.xdload_6_3.mpinv_nmos
Xmos_196 xtime.xdelaychain.dout_8 xtime.xdelaychain.dout_7 vdd vdd surrogate_pfet_freepdk45 l=5e-08 w=2.7e-07 scale_vth0={M196_vth0} scale_u0={M196_u0} scale_voff={M196_voff} * xtime.xdelaychain.xdinv7.mpinv_pmos
Xmos_197 xtime.xdelaychain.dout_8 xtime.xdelaychain.dout_7 vss vss surrogate_nfet_freepdk45 l=5e-08 w=9e-08 scale_vth0={M197_vth0} scale_u0={M197_u0} scale_voff={M197_voff} * xtime.xdelaychain.xdinv7.mpinv_nmos
Xmos_198 xtime.xdelaychain.n_7_0 xtime.xdelaychain.dout_8 vdd vdd surrogate_pfet_freepdk45 l=5e-08 w=2.7e-07 scale_vth0={M198_vth0} scale_u0={M198_u0} scale_voff={M198_voff} * xtime.xdelaychain.xdload_7_0.mpinv_pmos
Xmos_199 xtime.xdelaychain.n_7_0 xtime.xdelaychain.dout_8 vss vss surrogate_nfet_freepdk45 l=5e-08 w=9e-08 scale_vth0={M199_vth0} scale_u0={M199_u0} scale_voff={M199_voff} * xtime.xdelaychain.xdload_7_0.mpinv_nmos
Xmos_200 xtime.xdelaychain.n_7_1 xtime.xdelaychain.dout_8 vdd vdd surrogate_pfet_freepdk45 l=5e-08 w=2.7e-07 scale_vth0={M200_vth0} scale_u0={M200_u0} scale_voff={M200_voff} * xtime.xdelaychain.xdload_7_1.mpinv_pmos
Xmos_201 xtime.xdelaychain.n_7_1 xtime.xdelaychain.dout_8 vss vss surrogate_nfet_freepdk45 l=5e-08 w=9e-08 scale_vth0={M201_vth0} scale_u0={M201_u0} scale_voff={M201_voff} * xtime.xdelaychain.xdload_7_1.mpinv_nmos
Xmos_202 xtime.xdelaychain.n_7_2 xtime.xdelaychain.dout_8 vdd vdd surrogate_pfet_freepdk45 l=5e-08 w=2.7e-07 scale_vth0={M202_vth0} scale_u0={M202_u0} scale_voff={M202_voff} * xtime.xdelaychain.xdload_7_2.mpinv_pmos
Xmos_203 xtime.xdelaychain.n_7_2 xtime.xdelaychain.dout_8 vss vss surrogate_nfet_freepdk45 l=5e-08 w=9e-08 scale_vth0={M203_vth0} scale_u0={M203_u0} scale_voff={M203_voff} * xtime.xdelaychain.xdload_7_2.mpinv_nmos
Xmos_204 xtime.xdelaychain.n_7_3 xtime.xdelaychain.dout_8 vdd vdd surrogate_pfet_freepdk45 l=5e-08 w=2.7e-07 scale_vth0={M204_vth0} scale_u0={M204_u0} scale_voff={M204_voff} * xtime.xdelaychain.xdload_7_3.mpinv_pmos
Xmos_205 xtime.xdelaychain.n_7_3 xtime.xdelaychain.dout_8 vss vss surrogate_nfet_freepdk45 l=5e-08 w=9e-08 scale_vth0={M205_vth0} scale_u0={M205_u0} scale_voff={M205_voff} * xtime.xdelaychain.xdload_7_3.mpinv_nmos
Xmos_206 rbl_delay xtime.xdelaychain.dout_8 vdd vdd surrogate_pfet_freepdk45 l=5e-08 w=2.7e-07 scale_vth0={M206_vth0} scale_u0={M206_u0} scale_voff={M206_voff} * xtime.xdelaychain.xdinv8.mpinv_pmos
Xmos_207 rbl_delay xtime.xdelaychain.dout_8 vss vss surrogate_nfet_freepdk45 l=5e-08 w=9e-08 scale_vth0={M207_vth0} scale_u0={M207_u0} scale_voff={M207_voff} * xtime.xdelaychain.xdinv8.mpinv_nmos
Xmos_208 xtime.xdelaychain.n_8_0 rbl_delay vdd vdd surrogate_pfet_freepdk45 l=5e-08 w=2.7e-07 scale_vth0={M208_vth0} scale_u0={M208_u0} scale_voff={M208_voff} * xtime.xdelaychain.xdload_8_0.mpinv_pmos
Xmos_209 xtime.xdelaychain.n_8_0 rbl_delay vss vss surrogate_nfet_freepdk45 l=5e-08 w=9e-08 scale_vth0={M209_vth0} scale_u0={M209_u0} scale_voff={M209_voff} * xtime.xdelaychain.xdload_8_0.mpinv_nmos
Xmos_210 xtime.xdelaychain.n_8_1 rbl_delay vdd vdd surrogate_pfet_freepdk45 l=5e-08 w=2.7e-07 scale_vth0={M210_vth0} scale_u0={M210_u0} scale_voff={M210_voff} * xtime.xdelaychain.xdload_8_1.mpinv_pmos
Xmos_211 xtime.xdelaychain.n_8_1 rbl_delay vss vss surrogate_nfet_freepdk45 l=5e-08 w=9e-08 scale_vth0={M211_vth0} scale_u0={M211_u0} scale_voff={M211_voff} * xtime.xdelaychain.xdload_8_1.mpinv_nmos
Xmos_212 xtime.xdelaychain.n_8_2 rbl_delay vdd vdd surrogate_pfet_freepdk45 l=5e-08 w=2.7e-07 scale_vth0={M212_vth0} scale_u0={M212_u0} scale_voff={M212_voff} * xtime.xdelaychain.xdload_8_2.mpinv_pmos
Xmos_213 xtime.xdelaychain.n_8_2 rbl_delay vss vss surrogate_nfet_freepdk45 l=5e-08 w=9e-08 scale_vth0={M213_vth0} scale_u0={M213_u0} scale_voff={M213_voff} * xtime.xdelaychain.xdload_8_2.mpinv_nmos
Xmos_214 xtime.xdelaychain.n_8_3 rbl_delay vdd vdd surrogate_pfet_freepdk45 l=5e-08 w=2.7e-07 scale_vth0={M214_vth0} scale_u0={M214_u0} scale_voff={M214_voff} * xtime.xdelaychain.xdload_8_3.mpinv_pmos
Xmos_215 xtime.xdelaychain.n_8_3 rbl_delay vss vss surrogate_nfet_freepdk45 l=5e-08 w=9e-08 scale_vth0={M215_vth0} scale_u0={M215_u0} scale_voff={M215_voff} * xtime.xdelaychain.xdload_8_3.mpinv_nmos
Xmos_216 rbl_delay_bar rbl_delay vdd vdd surrogate_pfet_freepdk45 l=5e-08 w=2.7e-07 scale_vth0={M216_vth0} scale_u0={M216_u0} scale_voff={M216_voff} * xtime.xinv_rbl_delay_bar.mpinv_pmos
Xmos_217 rbl_delay_bar rbl_delay vss vss surrogate_nfet_freepdk45 l=5e-08 w=9e-08 scale_vth0={M217_vth0} scale_u0={M217_u0} scale_voff={M217_voff} * xtime.xinv_rbl_delay_bar.mpinv_nmos
Xmos_218 xtime.xw_en.zb_int rbl_delay_bar vdd vdd surrogate_pfet_freepdk45 l=5e-08 w=2.7e-07 scale_vth0={M218_vth0} scale_u0={M218_u0} scale_voff={M218_voff} * xtime.xw_en.xpnand3.mpnand3_pmos1
Xmos_219 xtime.xw_en.zb_int gated_clk_bar vdd vdd surrogate_pfet_freepdk45 l=5e-08 w=2.7e-07 scale_vth0={M219_vth0} scale_u0={M219_u0} scale_voff={M219_voff} * xtime.xw_en.xpnand3.mpnand3_pmos2
Xmos_220 xtime.xw_en.zb_int we vdd vdd surrogate_pfet_freepdk45 l=5e-08 w=2.7e-07 scale_vth0={M220_vth0} scale_u0={M220_u0} scale_voff={M220_voff} * xtime.xw_en.xpnand3.mpnand3_pmos3
Xmos_221 xtime.xw_en.zb_int rbl_delay_bar xtime.xw_en.xpnand3.net1 vss surrogate_nfet_freepdk45 l=5e-08 w=1.8e-07 scale_vth0={M221_vth0} scale_u0={M221_u0} scale_voff={M221_voff} * xtime.xw_en.xpnand3.mpnand3_nmos1
Xmos_222 xtime.xw_en.xpnand3.net1 gated_clk_bar xtime.xw_en.xpnand3.net2 vss surrogate_nfet_freepdk45 l=5e-08 w=1.8e-07 scale_vth0={M222_vth0} scale_u0={M222_u0} scale_voff={M222_voff} * xtime.xw_en.xpnand3.mpnand3_nmos2
Xmos_223 xtime.xw_en.xpnand3.net2 we vss vss surrogate_nfet_freepdk45 l=5e-08 w=1.8e-07 scale_vth0={M223_vth0} scale_u0={M223_u0} scale_voff={M223_voff} * xtime.xw_en.xpnand3.mpnand3_nmos3
Xmos_224 w_en xtime.xw_en.zb_int vdd vdd surrogate_pfet_freepdk45 l=5e-08 w=1.08e-06 scale_vth0={M224_vth0} scale_u0={M224_u0} scale_voff={M224_voff} * xtime.xw_en.xpinv.mpinv_pmos
Xmos_225 w_en xtime.xw_en.zb_int vss vss surrogate_nfet_freepdk45 l=5e-08 w=3.6e-07 scale_vth0={M225_vth0} scale_u0={M225_u0} scale_voff={M225_voff} * xtime.xw_en.xpinv.mpinv_nmos
Xmos_226 xtime.xs_en.zb_int rbl_delay vdd vdd surrogate_pfet_freepdk45 l=5e-08 w=2.7e-07 scale_vth0={M226_vth0} scale_u0={M226_u0} scale_voff={M226_voff} * xtime.xs_en.xpnand3.mpnand3_pmos1
Xmos_227 xtime.xs_en.zb_int gated_clk_bar vdd vdd surrogate_pfet_freepdk45 l=5e-08 w=2.7e-07 scale_vth0={M227_vth0} scale_u0={M227_u0} scale_voff={M227_voff} * xtime.xs_en.xpnand3.mpnand3_pmos2
Xmos_228 xtime.xs_en.zb_int we_bar vdd vdd surrogate_pfet_freepdk45 l=5e-08 w=2.7e-07 scale_vth0={M228_vth0} scale_u0={M228_u0} scale_voff={M228_voff} * xtime.xs_en.xpnand3.mpnand3_pmos3
Xmos_229 xtime.xs_en.zb_int rbl_delay xtime.xs_en.xpnand3.net1 vss surrogate_nfet_freepdk45 l=5e-08 w=1.8e-07 scale_vth0={M229_vth0} scale_u0={M229_u0} scale_voff={M229_voff} * xtime.xs_en.xpnand3.mpnand3_nmos1
Xmos_230 xtime.xs_en.xpnand3.net1 gated_clk_bar xtime.xs_en.xpnand3.net2 vss surrogate_nfet_freepdk45 l=5e-08 w=1.8e-07 scale_vth0={M230_vth0} scale_u0={M230_u0} scale_voff={M230_voff} * xtime.xs_en.xpnand3.mpnand3_nmos2
Xmos_231 xtime.xs_en.xpnand3.net2 we_bar vss vss surrogate_nfet_freepdk45 l=5e-08 w=1.8e-07 scale_vth0={M231_vth0} scale_u0={M231_u0} scale_voff={M231_voff} * xtime.xs_en.xpnand3.mpnand3_nmos3
Xmos_232 s_en xtime.xs_en.zb_int vdd vdd surrogate_pfet_freepdk45 l=5e-08 w=1.08e-06 scale_vth0={M232_vth0} scale_u0={M232_u0} scale_voff={M232_voff} * xtime.xs_en.xpinv.mpinv_pmos
Xmos_233 s_en xtime.xs_en.zb_int vss vss surrogate_nfet_freepdk45 l=5e-08 w=3.6e-07 scale_vth0={M233_vth0} scale_u0={M233_u0} scale_voff={M233_voff} * xtime.xs_en.xpinv.mpinv_nmos
Xmos_234 xtime.pre_unbuf gated_clk_buf vdd vdd surrogate_pfet_freepdk45 l=5e-08 w=2.7e-07 scale_vth0={M234_vth0} scale_u0={M234_u0} scale_voff={M234_voff} * xtime.xpre_unbuf.mpnand3_pmos1
Xmos_235 xtime.pre_unbuf rbl_delay vdd vdd surrogate_pfet_freepdk45 l=5e-08 w=2.7e-07 scale_vth0={M235_vth0} scale_u0={M235_u0} scale_voff={M235_voff} * xtime.xpre_unbuf.mpnand3_pmos2
Xmos_236 xtime.pre_unbuf xtime.wl_en_bar vdd vdd surrogate_pfet_freepdk45 l=5e-08 w=2.7e-07 scale_vth0={M236_vth0} scale_u0={M236_u0} scale_voff={M236_voff} * xtime.xpre_unbuf.mpnand3_pmos3
Xmos_237 xtime.pre_unbuf gated_clk_buf xtime.xpre_unbuf.net1 vss surrogate_nfet_freepdk45 l=5e-08 w=2.7e-07 scale_vth0={M237_vth0} scale_u0={M237_u0} scale_voff={M237_voff} * xtime.xpre_unbuf.mpnand3_nmos1
Xmos_238 xtime.xpre_unbuf.net1 rbl_delay xtime.xpre_unbuf.net2 vss surrogate_nfet_freepdk45 l=5e-08 w=2.7e-07 scale_vth0={M238_vth0} scale_u0={M238_u0} scale_voff={M238_voff} * xtime.xpre_unbuf.mpnand3_nmos2
Xmos_239 xtime.xpre_unbuf.net2 xtime.wl_en_bar vss vss surrogate_nfet_freepdk45 l=5e-08 w=2.7e-07 scale_vth0={M239_vth0} scale_u0={M239_u0} scale_voff={M239_voff} * xtime.xpre_unbuf.mpnand3_nmos3
Xmos_240 xtime.xpre.zb1_node xtime.pre_unbuf vdd vdd surrogate_pfet_freepdk45 l=5e-08 w=2.7e-07 scale_vth0={M240_vth0} scale_u0={M240_u0} scale_voff={M240_voff} * xtime.xpre.xbuf_inv1.mpinv_pmos
Xmos_241 xtime.xpre.zb1_node xtime.pre_unbuf vss vss surrogate_nfet_freepdk45 l=5e-08 w=9e-08 scale_vth0={M241_vth0} scale_u0={M241_u0} scale_voff={M241_voff} * xtime.xpre.xbuf_inv1.mpinv_nmos
Xmos_242 pre xtime.xpre.zb1_node vdd vdd surrogate_pfet_freepdk45 l=5e-08 w=8.1e-07 scale_vth0={M242_vth0} scale_u0={M242_u0} scale_voff={M242_voff} * xtime.xpre.xbuf_inv2.mpinv_pmos
Xmos_243 pre xtime.xpre.zb1_node vss vss surrogate_nfet_freepdk45 l=5e-08 w=2.7e-07 scale_vth0={M243_vth0} scale_u0={M243_u0} scale_voff={M243_voff} * xtime.xpre.xbuf_inv2.mpinv_nmos
Xmos_244 cs_bar cs_init_bar vdd vdd surrogate_pfet_freepdk45 l=5e-08 w=4.32e-06 scale_vth0={M244_vth0} scale_u0={M244_u0} scale_voff={M244_voff} * top.mcsinit_p
Xmos_245 cs cs_init vss vss surrogate_nfet_freepdk45 l=5e-08 w=1.44e-06 scale_vth0={M245_vth0} scale_u0={M245_u0} scale_voff={M245_voff} * top.mcsinit_n
VCSINIT cs_init VSS DC 0 PULSE(1.0 0 3.2e-09 2e-11 2e-11 2e-08 4e-08)
VCSINITB cs_init_bar VSS DC 0 PULSE(0 1.0 3.2e-09 2e-11 2e-11 2e-08 4e-08)
Xmos_246 xdecoder.xdec_0_0.a0b vss vdd vdd surrogate_pfet_freepdk45 l=5e-08 w=2.7e-07 scale_vth0={M246_vth0} scale_u0={M246_u0} scale_voff={M246_voff} * xdecoder.xdec_0_0.xinv_a1.mpinv_pmos
Xmos_247 xdecoder.xdec_0_0.a0b vss vss vss surrogate_nfet_freepdk45 l=5e-08 w=9e-08 scale_vth0={M247_vth0} scale_u0={M247_u0} scale_voff={M247_voff} * xdecoder.xdec_0_0.xinv_a1.mpinv_nmos
Xmos_248 xdecoder.xdec_0_0.a1b vss vdd vdd surrogate_pfet_freepdk45 l=5e-08 w=2.7e-07 scale_vth0={M248_vth0} scale_u0={M248_u0} scale_voff={M248_voff} * xdecoder.xdec_0_0.xinv_a2.mpinv_pmos
Xmos_249 xdecoder.xdec_0_0.a1b vss vss vss surrogate_nfet_freepdk45 l=5e-08 w=9e-08 scale_vth0={M249_vth0} scale_u0={M249_u0} scale_voff={M249_voff} * xdecoder.xdec_0_0.xinv_a2.mpinv_nmos
Xmos_250 xdecoder.xdec_0_0.a2b a_dff0 vdd vdd surrogate_pfet_freepdk45 l=5e-08 w=2.7e-07 scale_vth0={M250_vth0} scale_u0={M250_u0} scale_voff={M250_voff} * xdecoder.xdec_0_0.xinv_a3.mpinv_pmos
Xmos_251 xdecoder.xdec_0_0.a2b a_dff0 vss vss surrogate_nfet_freepdk45 l=5e-08 w=9e-08 scale_vth0={M251_vth0} scale_u0={M251_u0} scale_voff={M251_voff} * xdecoder.xdec_0_0.xinv_a3.mpinv_nmos
Xmos_252 xdecoder.xdec_0_0.xand0.zb_int xdecoder.xdec_0_0.a0b vdd vdd surrogate_pfet_freepdk45 l=5e-08 w=2.7e-07 scale_vth0={M252_vth0} scale_u0={M252_u0} scale_voff={M252_voff} * xdecoder.xdec_0_0.xand0.xpnand3.mpnand3_pmos1
Xmos_253 xdecoder.xdec_0_0.xand0.zb_int xdecoder.xdec_0_0.a1b vdd vdd surrogate_pfet_freepdk45 l=5e-08 w=2.7e-07 scale_vth0={M253_vth0} scale_u0={M253_u0} scale_voff={M253_voff} * xdecoder.xdec_0_0.xand0.xpnand3.mpnand3_pmos2
Xmos_254 xdecoder.xdec_0_0.xand0.zb_int xdecoder.xdec_0_0.a2b vdd vdd surrogate_pfet_freepdk45 l=5e-08 w=2.7e-07 scale_vth0={M254_vth0} scale_u0={M254_u0} scale_voff={M254_voff} * xdecoder.xdec_0_0.xand0.xpnand3.mpnand3_pmos3
Xmos_255 xdecoder.xdec_0_0.xand0.zb_int xdecoder.xdec_0_0.a0b xdecoder.xdec_0_0.xand0.xpnand3.net1 vss surrogate_nfet_freepdk45 l=5e-08 w=1.8e-07 scale_vth0={M255_vth0} scale_u0={M255_u0} scale_voff={M255_voff} * xdecoder.xdec_0_0.xand0.xpnand3.mpnand3_nmos1
Xmos_256 xdecoder.xdec_0_0.xand0.xpnand3.net1 xdecoder.xdec_0_0.a1b xdecoder.xdec_0_0.xand0.xpnand3.net2 vss surrogate_nfet_freepdk45 l=5e-08 w=1.8e-07 scale_vth0={M256_vth0} scale_u0={M256_u0} scale_voff={M256_voff} * xdecoder.xdec_0_0.xand0.xpnand3.mpnand3_nmos2
Xmos_257 xdecoder.xdec_0_0.xand0.xpnand3.net2 xdecoder.xdec_0_0.a2b vss vss surrogate_nfet_freepdk45 l=5e-08 w=1.8e-07 scale_vth0={M257_vth0} scale_u0={M257_u0} scale_voff={M257_voff} * xdecoder.xdec_0_0.xand0.xpnand3.mpnand3_nmos3
Xmos_258 xdecoder.xdec_0_0.wl0_pre xdecoder.xdec_0_0.xand0.zb_int vdd vdd surrogate_pfet_freepdk45 l=5e-08 w=2.7e-07 scale_vth0={M258_vth0} scale_u0={M258_u0} scale_voff={M258_voff} * xdecoder.xdec_0_0.xand0.xpinv.mpinv_pmos
Xmos_259 xdecoder.xdec_0_0.wl0_pre xdecoder.xdec_0_0.xand0.zb_int vss vss surrogate_nfet_freepdk45 l=5e-08 w=9e-08 scale_vth0={M259_vth0} scale_u0={M259_u0} scale_voff={M259_voff} * xdecoder.xdec_0_0.xand0.xpinv.mpinv_nmos
Xmos_260 xdecoder.xdec_0_0.xand_en0.zb_int xdecoder.xdec_0_0.wl0_pre vdd vdd surrogate_pfet_freepdk45 l=5e-08 w=2.7e-07 scale_vth0={M260_vth0} scale_u0={M260_u0} scale_voff={M260_voff} * xdecoder.xdec_0_0.xand_en0.xpnand3.mpnand2_pmos1
Xmos_261 xdecoder.xdec_0_0.xand_en0.zb_int vdd vdd vdd surrogate_pfet_freepdk45 l=5e-08 w=2.7e-07 scale_vth0={M261_vth0} scale_u0={M261_u0} scale_voff={M261_voff} * xdecoder.xdec_0_0.xand_en0.xpnand3.mpnand2_pmos2
Xmos_262 xdecoder.xdec_0_0.xand_en0.zb_int vdd xdecoder.xdec_0_0.xand_en0.xpnand3.net1 vss surrogate_nfet_freepdk45 l=5e-08 w=1.8e-07 scale_vth0={M262_vth0} scale_u0={M262_u0} scale_voff={M262_voff} * xdecoder.xdec_0_0.xand_en0.xpnand3.mpnand2_nmos1
Xmos_263 xdecoder.xdec_0_0.xand_en0.xpnand3.net1 xdecoder.xdec_0_0.wl0_pre vss vss surrogate_nfet_freepdk45 l=5e-08 w=1.8e-07 scale_vth0={M263_vth0} scale_u0={M263_u0} scale_voff={M263_voff} * xdecoder.xdec_0_0.xand_en0.xpnand3.mpnand2_nmos2
Xmos_264 dec_wl0 xdecoder.xdec_0_0.xand_en0.zb_int vdd vdd surrogate_pfet_freepdk45 l=5e-08 w=2.7e-07 scale_vth0={M264_vth0} scale_u0={M264_u0} scale_voff={M264_voff} * xdecoder.xdec_0_0.xand_en0.xpinv.mpinv_pmos
Xmos_265 dec_wl0 xdecoder.xdec_0_0.xand_en0.zb_int vss vss surrogate_nfet_freepdk45 l=5e-08 w=9e-08 scale_vth0={M265_vth0} scale_u0={M265_u0} scale_voff={M265_voff} * xdecoder.xdec_0_0.xand_en0.xpinv.mpinv_nmos
Xmos_266 xdecoder.xdec_0_0.xand1.zb_int xdecoder.xdec_0_0.a0b vdd vdd surrogate_pfet_freepdk45 l=5e-08 w=2.7e-07 scale_vth0={M266_vth0} scale_u0={M266_u0} scale_voff={M266_voff} * xdecoder.xdec_0_0.xand1.xpnand3.mpnand3_pmos1
Xmos_267 xdecoder.xdec_0_0.xand1.zb_int xdecoder.xdec_0_0.a1b vdd vdd surrogate_pfet_freepdk45 l=5e-08 w=2.7e-07 scale_vth0={M267_vth0} scale_u0={M267_u0} scale_voff={M267_voff} * xdecoder.xdec_0_0.xand1.xpnand3.mpnand3_pmos2
Xmos_268 xdecoder.xdec_0_0.xand1.zb_int a_dff0 vdd vdd surrogate_pfet_freepdk45 l=5e-08 w=2.7e-07 scale_vth0={M268_vth0} scale_u0={M268_u0} scale_voff={M268_voff} * xdecoder.xdec_0_0.xand1.xpnand3.mpnand3_pmos3
Xmos_269 xdecoder.xdec_0_0.xand1.zb_int xdecoder.xdec_0_0.a0b xdecoder.xdec_0_0.xand1.xpnand3.net1 vss surrogate_nfet_freepdk45 l=5e-08 w=1.8e-07 scale_vth0={M269_vth0} scale_u0={M269_u0} scale_voff={M269_voff} * xdecoder.xdec_0_0.xand1.xpnand3.mpnand3_nmos1
Xmos_270 xdecoder.xdec_0_0.xand1.xpnand3.net1 xdecoder.xdec_0_0.a1b xdecoder.xdec_0_0.xand1.xpnand3.net2 vss surrogate_nfet_freepdk45 l=5e-08 w=1.8e-07 scale_vth0={M270_vth0} scale_u0={M270_u0} scale_voff={M270_voff} * xdecoder.xdec_0_0.xand1.xpnand3.mpnand3_nmos2
Xmos_271 xdecoder.xdec_0_0.xand1.xpnand3.net2 a_dff0 vss vss surrogate_nfet_freepdk45 l=5e-08 w=1.8e-07 scale_vth0={M271_vth0} scale_u0={M271_u0} scale_voff={M271_voff} * xdecoder.xdec_0_0.xand1.xpnand3.mpnand3_nmos3
Xmos_272 xdecoder.xdec_0_0.wl1_pre xdecoder.xdec_0_0.xand1.zb_int vdd vdd surrogate_pfet_freepdk45 l=5e-08 w=2.7e-07 scale_vth0={M272_vth0} scale_u0={M272_u0} scale_voff={M272_voff} * xdecoder.xdec_0_0.xand1.xpinv.mpinv_pmos
Xmos_273 xdecoder.xdec_0_0.wl1_pre xdecoder.xdec_0_0.xand1.zb_int vss vss surrogate_nfet_freepdk45 l=5e-08 w=9e-08 scale_vth0={M273_vth0} scale_u0={M273_u0} scale_voff={M273_voff} * xdecoder.xdec_0_0.xand1.xpinv.mpinv_nmos
Xmos_274 xdecoder.xdec_0_0.xand_en1.zb_int xdecoder.xdec_0_0.wl1_pre vdd vdd surrogate_pfet_freepdk45 l=5e-08 w=2.7e-07 scale_vth0={M274_vth0} scale_u0={M274_u0} scale_voff={M274_voff} * xdecoder.xdec_0_0.xand_en1.xpnand3.mpnand2_pmos1
Xmos_275 xdecoder.xdec_0_0.xand_en1.zb_int vdd vdd vdd surrogate_pfet_freepdk45 l=5e-08 w=2.7e-07 scale_vth0={M275_vth0} scale_u0={M275_u0} scale_voff={M275_voff} * xdecoder.xdec_0_0.xand_en1.xpnand3.mpnand2_pmos2
Xmos_276 xdecoder.xdec_0_0.xand_en1.zb_int vdd xdecoder.xdec_0_0.xand_en1.xpnand3.net1 vss surrogate_nfet_freepdk45 l=5e-08 w=1.8e-07 scale_vth0={M276_vth0} scale_u0={M276_u0} scale_voff={M276_voff} * xdecoder.xdec_0_0.xand_en1.xpnand3.mpnand2_nmos1
Xmos_277 xdecoder.xdec_0_0.xand_en1.xpnand3.net1 xdecoder.xdec_0_0.wl1_pre vss vss surrogate_nfet_freepdk45 l=5e-08 w=1.8e-07 scale_vth0={M277_vth0} scale_u0={M277_u0} scale_voff={M277_voff} * xdecoder.xdec_0_0.xand_en1.xpnand3.mpnand2_nmos2
Xmos_278 xdecoder.nc_0_0_1 xdecoder.xdec_0_0.xand_en1.zb_int vdd vdd surrogate_pfet_freepdk45 l=5e-08 w=2.7e-07 scale_vth0={M278_vth0} scale_u0={M278_u0} scale_voff={M278_voff} * xdecoder.xdec_0_0.xand_en1.xpinv.mpinv_pmos
Xmos_279 xdecoder.nc_0_0_1 xdecoder.xdec_0_0.xand_en1.zb_int vss vss surrogate_nfet_freepdk45 l=5e-08 w=9e-08 scale_vth0={M279_vth0} scale_u0={M279_u0} scale_voff={M279_voff} * xdecoder.xdec_0_0.xand_en1.xpinv.mpinv_nmos
Xmos_280 xdecoder.xdec_0_0.xand2.zb_int xdecoder.xdec_0_0.a0b vdd vdd surrogate_pfet_freepdk45 l=5e-08 w=2.7e-07 scale_vth0={M280_vth0} scale_u0={M280_u0} scale_voff={M280_voff} * xdecoder.xdec_0_0.xand2.xpnand3.mpnand3_pmos1
Xmos_281 xdecoder.xdec_0_0.xand2.zb_int vss vdd vdd surrogate_pfet_freepdk45 l=5e-08 w=2.7e-07 scale_vth0={M281_vth0} scale_u0={M281_u0} scale_voff={M281_voff} * xdecoder.xdec_0_0.xand2.xpnand3.mpnand3_pmos2
Xmos_282 xdecoder.xdec_0_0.xand2.zb_int xdecoder.xdec_0_0.a2b vdd vdd surrogate_pfet_freepdk45 l=5e-08 w=2.7e-07 scale_vth0={M282_vth0} scale_u0={M282_u0} scale_voff={M282_voff} * xdecoder.xdec_0_0.xand2.xpnand3.mpnand3_pmos3
Xmos_283 xdecoder.xdec_0_0.xand2.zb_int xdecoder.xdec_0_0.a0b xdecoder.xdec_0_0.xand2.xpnand3.net1 vss surrogate_nfet_freepdk45 l=5e-08 w=1.8e-07 scale_vth0={M283_vth0} scale_u0={M283_u0} scale_voff={M283_voff} * xdecoder.xdec_0_0.xand2.xpnand3.mpnand3_nmos1
Xmos_284 xdecoder.xdec_0_0.xand2.xpnand3.net1 vss xdecoder.xdec_0_0.xand2.xpnand3.net2 vss surrogate_nfet_freepdk45 l=5e-08 w=1.8e-07 scale_vth0={M284_vth0} scale_u0={M284_u0} scale_voff={M284_voff} * xdecoder.xdec_0_0.xand2.xpnand3.mpnand3_nmos2
Xmos_285 xdecoder.xdec_0_0.xand2.xpnand3.net2 xdecoder.xdec_0_0.a2b vss vss surrogate_nfet_freepdk45 l=5e-08 w=1.8e-07 scale_vth0={M285_vth0} scale_u0={M285_u0} scale_voff={M285_voff} * xdecoder.xdec_0_0.xand2.xpnand3.mpnand3_nmos3
Xmos_286 xdecoder.xdec_0_0.wl2_pre xdecoder.xdec_0_0.xand2.zb_int vdd vdd surrogate_pfet_freepdk45 l=5e-08 w=2.7e-07 scale_vth0={M286_vth0} scale_u0={M286_u0} scale_voff={M286_voff} * xdecoder.xdec_0_0.xand2.xpinv.mpinv_pmos
Xmos_287 xdecoder.xdec_0_0.wl2_pre xdecoder.xdec_0_0.xand2.zb_int vss vss surrogate_nfet_freepdk45 l=5e-08 w=9e-08 scale_vth0={M287_vth0} scale_u0={M287_u0} scale_voff={M287_voff} * xdecoder.xdec_0_0.xand2.xpinv.mpinv_nmos
Xmos_288 xdecoder.xdec_0_0.xand_en2.zb_int xdecoder.xdec_0_0.wl2_pre vdd vdd surrogate_pfet_freepdk45 l=5e-08 w=2.7e-07 scale_vth0={M288_vth0} scale_u0={M288_u0} scale_voff={M288_voff} * xdecoder.xdec_0_0.xand_en2.xpnand3.mpnand2_pmos1
Xmos_289 xdecoder.xdec_0_0.xand_en2.zb_int vdd vdd vdd surrogate_pfet_freepdk45 l=5e-08 w=2.7e-07 scale_vth0={M289_vth0} scale_u0={M289_u0} scale_voff={M289_voff} * xdecoder.xdec_0_0.xand_en2.xpnand3.mpnand2_pmos2
Xmos_290 xdecoder.xdec_0_0.xand_en2.zb_int vdd xdecoder.xdec_0_0.xand_en2.xpnand3.net1 vss surrogate_nfet_freepdk45 l=5e-08 w=1.8e-07 scale_vth0={M290_vth0} scale_u0={M290_u0} scale_voff={M290_voff} * xdecoder.xdec_0_0.xand_en2.xpnand3.mpnand2_nmos1
Xmos_291 xdecoder.xdec_0_0.xand_en2.xpnand3.net1 xdecoder.xdec_0_0.wl2_pre vss vss surrogate_nfet_freepdk45 l=5e-08 w=1.8e-07 scale_vth0={M291_vth0} scale_u0={M291_u0} scale_voff={M291_voff} * xdecoder.xdec_0_0.xand_en2.xpnand3.mpnand2_nmos2
Xmos_292 xdecoder.nc_0_0_2 xdecoder.xdec_0_0.xand_en2.zb_int vdd vdd surrogate_pfet_freepdk45 l=5e-08 w=2.7e-07 scale_vth0={M292_vth0} scale_u0={M292_u0} scale_voff={M292_voff} * xdecoder.xdec_0_0.xand_en2.xpinv.mpinv_pmos
Xmos_293 xdecoder.nc_0_0_2 xdecoder.xdec_0_0.xand_en2.zb_int vss vss surrogate_nfet_freepdk45 l=5e-08 w=9e-08 scale_vth0={M293_vth0} scale_u0={M293_u0} scale_voff={M293_voff} * xdecoder.xdec_0_0.xand_en2.xpinv.mpinv_nmos
Xmos_294 xdecoder.xdec_0_0.xand3.zb_int xdecoder.xdec_0_0.a0b vdd vdd surrogate_pfet_freepdk45 l=5e-08 w=2.7e-07 scale_vth0={M294_vth0} scale_u0={M294_u0} scale_voff={M294_voff} * xdecoder.xdec_0_0.xand3.xpnand3.mpnand3_pmos1
Xmos_295 xdecoder.xdec_0_0.xand3.zb_int vss vdd vdd surrogate_pfet_freepdk45 l=5e-08 w=2.7e-07 scale_vth0={M295_vth0} scale_u0={M295_u0} scale_voff={M295_voff} * xdecoder.xdec_0_0.xand3.xpnand3.mpnand3_pmos2
Xmos_296 xdecoder.xdec_0_0.xand3.zb_int a_dff0 vdd vdd surrogate_pfet_freepdk45 l=5e-08 w=2.7e-07 scale_vth0={M296_vth0} scale_u0={M296_u0} scale_voff={M296_voff} * xdecoder.xdec_0_0.xand3.xpnand3.mpnand3_pmos3
Xmos_297 xdecoder.xdec_0_0.xand3.zb_int xdecoder.xdec_0_0.a0b xdecoder.xdec_0_0.xand3.xpnand3.net1 vss surrogate_nfet_freepdk45 l=5e-08 w=1.8e-07 scale_vth0={M297_vth0} scale_u0={M297_u0} scale_voff={M297_voff} * xdecoder.xdec_0_0.xand3.xpnand3.mpnand3_nmos1
Xmos_298 xdecoder.xdec_0_0.xand3.xpnand3.net1 vss xdecoder.xdec_0_0.xand3.xpnand3.net2 vss surrogate_nfet_freepdk45 l=5e-08 w=1.8e-07 scale_vth0={M298_vth0} scale_u0={M298_u0} scale_voff={M298_voff} * xdecoder.xdec_0_0.xand3.xpnand3.mpnand3_nmos2
Xmos_299 xdecoder.xdec_0_0.xand3.xpnand3.net2 a_dff0 vss vss surrogate_nfet_freepdk45 l=5e-08 w=1.8e-07 scale_vth0={M299_vth0} scale_u0={M299_u0} scale_voff={M299_voff} * xdecoder.xdec_0_0.xand3.xpnand3.mpnand3_nmos3
Xmos_300 xdecoder.xdec_0_0.wl3_pre xdecoder.xdec_0_0.xand3.zb_int vdd vdd surrogate_pfet_freepdk45 l=5e-08 w=2.7e-07 scale_vth0={M300_vth0} scale_u0={M300_u0} scale_voff={M300_voff} * xdecoder.xdec_0_0.xand3.xpinv.mpinv_pmos
Xmos_301 xdecoder.xdec_0_0.wl3_pre xdecoder.xdec_0_0.xand3.zb_int vss vss surrogate_nfet_freepdk45 l=5e-08 w=9e-08 scale_vth0={M301_vth0} scale_u0={M301_u0} scale_voff={M301_voff} * xdecoder.xdec_0_0.xand3.xpinv.mpinv_nmos
Xmos_302 xdecoder.xdec_0_0.xand_en3.zb_int xdecoder.xdec_0_0.wl3_pre vdd vdd surrogate_pfet_freepdk45 l=5e-08 w=2.7e-07 scale_vth0={M302_vth0} scale_u0={M302_u0} scale_voff={M302_voff} * xdecoder.xdec_0_0.xand_en3.xpnand3.mpnand2_pmos1
Xmos_303 xdecoder.xdec_0_0.xand_en3.zb_int vdd vdd vdd surrogate_pfet_freepdk45 l=5e-08 w=2.7e-07 scale_vth0={M303_vth0} scale_u0={M303_u0} scale_voff={M303_voff} * xdecoder.xdec_0_0.xand_en3.xpnand3.mpnand2_pmos2
Xmos_304 xdecoder.xdec_0_0.xand_en3.zb_int vdd xdecoder.xdec_0_0.xand_en3.xpnand3.net1 vss surrogate_nfet_freepdk45 l=5e-08 w=1.8e-07 scale_vth0={M304_vth0} scale_u0={M304_u0} scale_voff={M304_voff} * xdecoder.xdec_0_0.xand_en3.xpnand3.mpnand2_nmos1
Xmos_305 xdecoder.xdec_0_0.xand_en3.xpnand3.net1 xdecoder.xdec_0_0.wl3_pre vss vss surrogate_nfet_freepdk45 l=5e-08 w=1.8e-07 scale_vth0={M305_vth0} scale_u0={M305_u0} scale_voff={M305_voff} * xdecoder.xdec_0_0.xand_en3.xpnand3.mpnand2_nmos2
Xmos_306 xdecoder.nc_0_0_3 xdecoder.xdec_0_0.xand_en3.zb_int vdd vdd surrogate_pfet_freepdk45 l=5e-08 w=2.7e-07 scale_vth0={M306_vth0} scale_u0={M306_u0} scale_voff={M306_voff} * xdecoder.xdec_0_0.xand_en3.xpinv.mpinv_pmos
Xmos_307 xdecoder.nc_0_0_3 xdecoder.xdec_0_0.xand_en3.zb_int vss vss surrogate_nfet_freepdk45 l=5e-08 w=9e-08 scale_vth0={M307_vth0} scale_u0={M307_u0} scale_voff={M307_voff} * xdecoder.xdec_0_0.xand_en3.xpinv.mpinv_nmos
Xmos_308 xdecoder.xdec_0_0.xand4.zb_int vss vdd vdd surrogate_pfet_freepdk45 l=5e-08 w=2.7e-07 scale_vth0={M308_vth0} scale_u0={M308_u0} scale_voff={M308_voff} * xdecoder.xdec_0_0.xand4.xpnand3.mpnand3_pmos1
Xmos_309 xdecoder.xdec_0_0.xand4.zb_int xdecoder.xdec_0_0.a1b vdd vdd surrogate_pfet_freepdk45 l=5e-08 w=2.7e-07 scale_vth0={M309_vth0} scale_u0={M309_u0} scale_voff={M309_voff} * xdecoder.xdec_0_0.xand4.xpnand3.mpnand3_pmos2
Xmos_310 xdecoder.xdec_0_0.xand4.zb_int xdecoder.xdec_0_0.a2b vdd vdd surrogate_pfet_freepdk45 l=5e-08 w=2.7e-07 scale_vth0={M310_vth0} scale_u0={M310_u0} scale_voff={M310_voff} * xdecoder.xdec_0_0.xand4.xpnand3.mpnand3_pmos3
Xmos_311 xdecoder.xdec_0_0.xand4.zb_int vss xdecoder.xdec_0_0.xand4.xpnand3.net1 vss surrogate_nfet_freepdk45 l=5e-08 w=1.8e-07 scale_vth0={M311_vth0} scale_u0={M311_u0} scale_voff={M311_voff} * xdecoder.xdec_0_0.xand4.xpnand3.mpnand3_nmos1
Xmos_312 xdecoder.xdec_0_0.xand4.xpnand3.net1 xdecoder.xdec_0_0.a1b xdecoder.xdec_0_0.xand4.xpnand3.net2 vss surrogate_nfet_freepdk45 l=5e-08 w=1.8e-07 scale_vth0={M312_vth0} scale_u0={M312_u0} scale_voff={M312_voff} * xdecoder.xdec_0_0.xand4.xpnand3.mpnand3_nmos2
Xmos_313 xdecoder.xdec_0_0.xand4.xpnand3.net2 xdecoder.xdec_0_0.a2b vss vss surrogate_nfet_freepdk45 l=5e-08 w=1.8e-07 scale_vth0={M313_vth0} scale_u0={M313_u0} scale_voff={M313_voff} * xdecoder.xdec_0_0.xand4.xpnand3.mpnand3_nmos3
Xmos_314 xdecoder.xdec_0_0.wl4_pre xdecoder.xdec_0_0.xand4.zb_int vdd vdd surrogate_pfet_freepdk45 l=5e-08 w=2.7e-07 scale_vth0={M314_vth0} scale_u0={M314_u0} scale_voff={M314_voff} * xdecoder.xdec_0_0.xand4.xpinv.mpinv_pmos
Xmos_315 xdecoder.xdec_0_0.wl4_pre xdecoder.xdec_0_0.xand4.zb_int vss vss surrogate_nfet_freepdk45 l=5e-08 w=9e-08 scale_vth0={M315_vth0} scale_u0={M315_u0} scale_voff={M315_voff} * xdecoder.xdec_0_0.xand4.xpinv.mpinv_nmos
Xmos_316 xdecoder.xdec_0_0.xand_en4.zb_int xdecoder.xdec_0_0.wl4_pre vdd vdd surrogate_pfet_freepdk45 l=5e-08 w=2.7e-07 scale_vth0={M316_vth0} scale_u0={M316_u0} scale_voff={M316_voff} * xdecoder.xdec_0_0.xand_en4.xpnand3.mpnand2_pmos1
Xmos_317 xdecoder.xdec_0_0.xand_en4.zb_int vdd vdd vdd surrogate_pfet_freepdk45 l=5e-08 w=2.7e-07 scale_vth0={M317_vth0} scale_u0={M317_u0} scale_voff={M317_voff} * xdecoder.xdec_0_0.xand_en4.xpnand3.mpnand2_pmos2
Xmos_318 xdecoder.xdec_0_0.xand_en4.zb_int vdd xdecoder.xdec_0_0.xand_en4.xpnand3.net1 vss surrogate_nfet_freepdk45 l=5e-08 w=1.8e-07 scale_vth0={M318_vth0} scale_u0={M318_u0} scale_voff={M318_voff} * xdecoder.xdec_0_0.xand_en4.xpnand3.mpnand2_nmos1
Xmos_319 xdecoder.xdec_0_0.xand_en4.xpnand3.net1 xdecoder.xdec_0_0.wl4_pre vss vss surrogate_nfet_freepdk45 l=5e-08 w=1.8e-07 scale_vth0={M319_vth0} scale_u0={M319_u0} scale_voff={M319_voff} * xdecoder.xdec_0_0.xand_en4.xpnand3.mpnand2_nmos2
Xmos_320 xdecoder.nc_0_0_4 xdecoder.xdec_0_0.xand_en4.zb_int vdd vdd surrogate_pfet_freepdk45 l=5e-08 w=2.7e-07 scale_vth0={M320_vth0} scale_u0={M320_u0} scale_voff={M320_voff} * xdecoder.xdec_0_0.xand_en4.xpinv.mpinv_pmos
Xmos_321 xdecoder.nc_0_0_4 xdecoder.xdec_0_0.xand_en4.zb_int vss vss surrogate_nfet_freepdk45 l=5e-08 w=9e-08 scale_vth0={M321_vth0} scale_u0={M321_u0} scale_voff={M321_voff} * xdecoder.xdec_0_0.xand_en4.xpinv.mpinv_nmos
Xmos_322 xdecoder.xdec_0_0.xand5.zb_int vss vdd vdd surrogate_pfet_freepdk45 l=5e-08 w=2.7e-07 scale_vth0={M322_vth0} scale_u0={M322_u0} scale_voff={M322_voff} * xdecoder.xdec_0_0.xand5.xpnand3.mpnand3_pmos1
Xmos_323 xdecoder.xdec_0_0.xand5.zb_int xdecoder.xdec_0_0.a1b vdd vdd surrogate_pfet_freepdk45 l=5e-08 w=2.7e-07 scale_vth0={M323_vth0} scale_u0={M323_u0} scale_voff={M323_voff} * xdecoder.xdec_0_0.xand5.xpnand3.mpnand3_pmos2
Xmos_324 xdecoder.xdec_0_0.xand5.zb_int a_dff0 vdd vdd surrogate_pfet_freepdk45 l=5e-08 w=2.7e-07 scale_vth0={M324_vth0} scale_u0={M324_u0} scale_voff={M324_voff} * xdecoder.xdec_0_0.xand5.xpnand3.mpnand3_pmos3
Xmos_325 xdecoder.xdec_0_0.xand5.zb_int vss xdecoder.xdec_0_0.xand5.xpnand3.net1 vss surrogate_nfet_freepdk45 l=5e-08 w=1.8e-07 scale_vth0={M325_vth0} scale_u0={M325_u0} scale_voff={M325_voff} * xdecoder.xdec_0_0.xand5.xpnand3.mpnand3_nmos1
Xmos_326 xdecoder.xdec_0_0.xand5.xpnand3.net1 xdecoder.xdec_0_0.a1b xdecoder.xdec_0_0.xand5.xpnand3.net2 vss surrogate_nfet_freepdk45 l=5e-08 w=1.8e-07 scale_vth0={M326_vth0} scale_u0={M326_u0} scale_voff={M326_voff} * xdecoder.xdec_0_0.xand5.xpnand3.mpnand3_nmos2
Xmos_327 xdecoder.xdec_0_0.xand5.xpnand3.net2 a_dff0 vss vss surrogate_nfet_freepdk45 l=5e-08 w=1.8e-07 scale_vth0={M327_vth0} scale_u0={M327_u0} scale_voff={M327_voff} * xdecoder.xdec_0_0.xand5.xpnand3.mpnand3_nmos3
Xmos_328 xdecoder.xdec_0_0.wl5_pre xdecoder.xdec_0_0.xand5.zb_int vdd vdd surrogate_pfet_freepdk45 l=5e-08 w=2.7e-07 scale_vth0={M328_vth0} scale_u0={M328_u0} scale_voff={M328_voff} * xdecoder.xdec_0_0.xand5.xpinv.mpinv_pmos
Xmos_329 xdecoder.xdec_0_0.wl5_pre xdecoder.xdec_0_0.xand5.zb_int vss vss surrogate_nfet_freepdk45 l=5e-08 w=9e-08 scale_vth0={M329_vth0} scale_u0={M329_u0} scale_voff={M329_voff} * xdecoder.xdec_0_0.xand5.xpinv.mpinv_nmos
Xmos_330 xdecoder.xdec_0_0.xand_en5.zb_int xdecoder.xdec_0_0.wl5_pre vdd vdd surrogate_pfet_freepdk45 l=5e-08 w=2.7e-07 scale_vth0={M330_vth0} scale_u0={M330_u0} scale_voff={M330_voff} * xdecoder.xdec_0_0.xand_en5.xpnand3.mpnand2_pmos1
Xmos_331 xdecoder.xdec_0_0.xand_en5.zb_int vdd vdd vdd surrogate_pfet_freepdk45 l=5e-08 w=2.7e-07 scale_vth0={M331_vth0} scale_u0={M331_u0} scale_voff={M331_voff} * xdecoder.xdec_0_0.xand_en5.xpnand3.mpnand2_pmos2
Xmos_332 xdecoder.xdec_0_0.xand_en5.zb_int vdd xdecoder.xdec_0_0.xand_en5.xpnand3.net1 vss surrogate_nfet_freepdk45 l=5e-08 w=1.8e-07 scale_vth0={M332_vth0} scale_u0={M332_u0} scale_voff={M332_voff} * xdecoder.xdec_0_0.xand_en5.xpnand3.mpnand2_nmos1
Xmos_333 xdecoder.xdec_0_0.xand_en5.xpnand3.net1 xdecoder.xdec_0_0.wl5_pre vss vss surrogate_nfet_freepdk45 l=5e-08 w=1.8e-07 scale_vth0={M333_vth0} scale_u0={M333_u0} scale_voff={M333_voff} * xdecoder.xdec_0_0.xand_en5.xpnand3.mpnand2_nmos2
Xmos_334 xdecoder.nc_0_0_5 xdecoder.xdec_0_0.xand_en5.zb_int vdd vdd surrogate_pfet_freepdk45 l=5e-08 w=2.7e-07 scale_vth0={M334_vth0} scale_u0={M334_u0} scale_voff={M334_voff} * xdecoder.xdec_0_0.xand_en5.xpinv.mpinv_pmos
Xmos_335 xdecoder.nc_0_0_5 xdecoder.xdec_0_0.xand_en5.zb_int vss vss surrogate_nfet_freepdk45 l=5e-08 w=9e-08 scale_vth0={M335_vth0} scale_u0={M335_u0} scale_voff={M335_voff} * xdecoder.xdec_0_0.xand_en5.xpinv.mpinv_nmos
Xmos_336 xdecoder.xdec_0_0.xand6.zb_int vss vdd vdd surrogate_pfet_freepdk45 l=5e-08 w=2.7e-07 scale_vth0={M336_vth0} scale_u0={M336_u0} scale_voff={M336_voff} * xdecoder.xdec_0_0.xand6.xpnand3.mpnand3_pmos1
Xmos_337 xdecoder.xdec_0_0.xand6.zb_int vss vdd vdd surrogate_pfet_freepdk45 l=5e-08 w=2.7e-07 scale_vth0={M337_vth0} scale_u0={M337_u0} scale_voff={M337_voff} * xdecoder.xdec_0_0.xand6.xpnand3.mpnand3_pmos2
Xmos_338 xdecoder.xdec_0_0.xand6.zb_int xdecoder.xdec_0_0.a2b vdd vdd surrogate_pfet_freepdk45 l=5e-08 w=2.7e-07 scale_vth0={M338_vth0} scale_u0={M338_u0} scale_voff={M338_voff} * xdecoder.xdec_0_0.xand6.xpnand3.mpnand3_pmos3
Xmos_339 xdecoder.xdec_0_0.xand6.zb_int vss xdecoder.xdec_0_0.xand6.xpnand3.net1 vss surrogate_nfet_freepdk45 l=5e-08 w=1.8e-07 scale_vth0={M339_vth0} scale_u0={M339_u0} scale_voff={M339_voff} * xdecoder.xdec_0_0.xand6.xpnand3.mpnand3_nmos1
Xmos_340 xdecoder.xdec_0_0.xand6.xpnand3.net1 vss xdecoder.xdec_0_0.xand6.xpnand3.net2 vss surrogate_nfet_freepdk45 l=5e-08 w=1.8e-07 scale_vth0={M340_vth0} scale_u0={M340_u0} scale_voff={M340_voff} * xdecoder.xdec_0_0.xand6.xpnand3.mpnand3_nmos2
Xmos_341 xdecoder.xdec_0_0.xand6.xpnand3.net2 xdecoder.xdec_0_0.a2b vss vss surrogate_nfet_freepdk45 l=5e-08 w=1.8e-07 scale_vth0={M341_vth0} scale_u0={M341_u0} scale_voff={M341_voff} * xdecoder.xdec_0_0.xand6.xpnand3.mpnand3_nmos3
Xmos_342 xdecoder.xdec_0_0.wl6_pre xdecoder.xdec_0_0.xand6.zb_int vdd vdd surrogate_pfet_freepdk45 l=5e-08 w=2.7e-07 scale_vth0={M342_vth0} scale_u0={M342_u0} scale_voff={M342_voff} * xdecoder.xdec_0_0.xand6.xpinv.mpinv_pmos
Xmos_343 xdecoder.xdec_0_0.wl6_pre xdecoder.xdec_0_0.xand6.zb_int vss vss surrogate_nfet_freepdk45 l=5e-08 w=9e-08 scale_vth0={M343_vth0} scale_u0={M343_u0} scale_voff={M343_voff} * xdecoder.xdec_0_0.xand6.xpinv.mpinv_nmos
Xmos_344 xdecoder.xdec_0_0.xand_en6.zb_int xdecoder.xdec_0_0.wl6_pre vdd vdd surrogate_pfet_freepdk45 l=5e-08 w=2.7e-07 scale_vth0={M344_vth0} scale_u0={M344_u0} scale_voff={M344_voff} * xdecoder.xdec_0_0.xand_en6.xpnand3.mpnand2_pmos1
Xmos_345 xdecoder.xdec_0_0.xand_en6.zb_int vdd vdd vdd surrogate_pfet_freepdk45 l=5e-08 w=2.7e-07 scale_vth0={M345_vth0} scale_u0={M345_u0} scale_voff={M345_voff} * xdecoder.xdec_0_0.xand_en6.xpnand3.mpnand2_pmos2
Xmos_346 xdecoder.xdec_0_0.xand_en6.zb_int vdd xdecoder.xdec_0_0.xand_en6.xpnand3.net1 vss surrogate_nfet_freepdk45 l=5e-08 w=1.8e-07 scale_vth0={M346_vth0} scale_u0={M346_u0} scale_voff={M346_voff} * xdecoder.xdec_0_0.xand_en6.xpnand3.mpnand2_nmos1
Xmos_347 xdecoder.xdec_0_0.xand_en6.xpnand3.net1 xdecoder.xdec_0_0.wl6_pre vss vss surrogate_nfet_freepdk45 l=5e-08 w=1.8e-07 scale_vth0={M347_vth0} scale_u0={M347_u0} scale_voff={M347_voff} * xdecoder.xdec_0_0.xand_en6.xpnand3.mpnand2_nmos2
Xmos_348 xdecoder.nc_0_0_6 xdecoder.xdec_0_0.xand_en6.zb_int vdd vdd surrogate_pfet_freepdk45 l=5e-08 w=2.7e-07 scale_vth0={M348_vth0} scale_u0={M348_u0} scale_voff={M348_voff} * xdecoder.xdec_0_0.xand_en6.xpinv.mpinv_pmos
Xmos_349 xdecoder.nc_0_0_6 xdecoder.xdec_0_0.xand_en6.zb_int vss vss surrogate_nfet_freepdk45 l=5e-08 w=9e-08 scale_vth0={M349_vth0} scale_u0={M349_u0} scale_voff={M349_voff} * xdecoder.xdec_0_0.xand_en6.xpinv.mpinv_nmos
Xmos_350 xdecoder.xdec_0_0.xand7.zb_int vss vdd vdd surrogate_pfet_freepdk45 l=5e-08 w=2.7e-07 scale_vth0={M350_vth0} scale_u0={M350_u0} scale_voff={M350_voff} * xdecoder.xdec_0_0.xand7.xpnand3.mpnand3_pmos1
Xmos_351 xdecoder.xdec_0_0.xand7.zb_int vss vdd vdd surrogate_pfet_freepdk45 l=5e-08 w=2.7e-07 scale_vth0={M351_vth0} scale_u0={M351_u0} scale_voff={M351_voff} * xdecoder.xdec_0_0.xand7.xpnand3.mpnand3_pmos2
Xmos_352 xdecoder.xdec_0_0.xand7.zb_int a_dff0 vdd vdd surrogate_pfet_freepdk45 l=5e-08 w=2.7e-07 scale_vth0={M352_vth0} scale_u0={M352_u0} scale_voff={M352_voff} * xdecoder.xdec_0_0.xand7.xpnand3.mpnand3_pmos3
Xmos_353 xdecoder.xdec_0_0.xand7.zb_int vss xdecoder.xdec_0_0.xand7.xpnand3.net1 vss surrogate_nfet_freepdk45 l=5e-08 w=1.8e-07 scale_vth0={M353_vth0} scale_u0={M353_u0} scale_voff={M353_voff} * xdecoder.xdec_0_0.xand7.xpnand3.mpnand3_nmos1
Xmos_354 xdecoder.xdec_0_0.xand7.xpnand3.net1 vss xdecoder.xdec_0_0.xand7.xpnand3.net2 vss surrogate_nfet_freepdk45 l=5e-08 w=1.8e-07 scale_vth0={M354_vth0} scale_u0={M354_u0} scale_voff={M354_voff} * xdecoder.xdec_0_0.xand7.xpnand3.mpnand3_nmos2
Xmos_355 xdecoder.xdec_0_0.xand7.xpnand3.net2 a_dff0 vss vss surrogate_nfet_freepdk45 l=5e-08 w=1.8e-07 scale_vth0={M355_vth0} scale_u0={M355_u0} scale_voff={M355_voff} * xdecoder.xdec_0_0.xand7.xpnand3.mpnand3_nmos3
Xmos_356 xdecoder.xdec_0_0.wl7_pre xdecoder.xdec_0_0.xand7.zb_int vdd vdd surrogate_pfet_freepdk45 l=5e-08 w=2.7e-07 scale_vth0={M356_vth0} scale_u0={M356_u0} scale_voff={M356_voff} * xdecoder.xdec_0_0.xand7.xpinv.mpinv_pmos
Xmos_357 xdecoder.xdec_0_0.wl7_pre xdecoder.xdec_0_0.xand7.zb_int vss vss surrogate_nfet_freepdk45 l=5e-08 w=9e-08 scale_vth0={M357_vth0} scale_u0={M357_u0} scale_voff={M357_voff} * xdecoder.xdec_0_0.xand7.xpinv.mpinv_nmos
Xmos_358 xdecoder.xdec_0_0.xand_en7.zb_int xdecoder.xdec_0_0.wl7_pre vdd vdd surrogate_pfet_freepdk45 l=5e-08 w=2.7e-07 scale_vth0={M358_vth0} scale_u0={M358_u0} scale_voff={M358_voff} * xdecoder.xdec_0_0.xand_en7.xpnand3.mpnand2_pmos1
Xmos_359 xdecoder.xdec_0_0.xand_en7.zb_int vdd vdd vdd surrogate_pfet_freepdk45 l=5e-08 w=2.7e-07 scale_vth0={M359_vth0} scale_u0={M359_u0} scale_voff={M359_voff} * xdecoder.xdec_0_0.xand_en7.xpnand3.mpnand2_pmos2
Xmos_360 xdecoder.xdec_0_0.xand_en7.zb_int vdd xdecoder.xdec_0_0.xand_en7.xpnand3.net1 vss surrogate_nfet_freepdk45 l=5e-08 w=1.8e-07 scale_vth0={M360_vth0} scale_u0={M360_u0} scale_voff={M360_voff} * xdecoder.xdec_0_0.xand_en7.xpnand3.mpnand2_nmos1
Xmos_361 xdecoder.xdec_0_0.xand_en7.xpnand3.net1 xdecoder.xdec_0_0.wl7_pre vss vss surrogate_nfet_freepdk45 l=5e-08 w=1.8e-07 scale_vth0={M361_vth0} scale_u0={M361_u0} scale_voff={M361_voff} * xdecoder.xdec_0_0.xand_en7.xpnand3.mpnand2_nmos2
Xmos_362 xdecoder.nc_0_0_7 xdecoder.xdec_0_0.xand_en7.zb_int vdd vdd surrogate_pfet_freepdk45 l=5e-08 w=2.7e-07 scale_vth0={M362_vth0} scale_u0={M362_u0} scale_voff={M362_voff} * xdecoder.xdec_0_0.xand_en7.xpinv.mpinv_pmos
Xmos_363 xdecoder.nc_0_0_7 xdecoder.xdec_0_0.xand_en7.zb_int vss vss surrogate_nfet_freepdk45 l=5e-08 w=9e-08 scale_vth0={M363_vth0} scale_u0={M363_u0} scale_voff={M363_voff} * xdecoder.xdec_0_0.xand_en7.xpinv.mpinv_nmos
Xmos_364 xwl_drv_0.zb_int dec_wl0 vdd vdd surrogate_pfet_freepdk45 l=5e-08 w=2.7e-07 scale_vth0={M364_vth0} scale_u0={M364_u0} scale_voff={M364_voff} * xwl_drv_0.xpnand2.mpnand2_pmos1
Xmos_365 xwl_drv_0.zb_int wl_en vdd vdd surrogate_pfet_freepdk45 l=5e-08 w=2.7e-07 scale_vth0={M365_vth0} scale_u0={M365_u0} scale_voff={M365_voff} * xwl_drv_0.xpnand2.mpnand2_pmos2
Xmos_366 xwl_drv_0.zb_int wl_en xwl_drv_0.xpnand2.net1 vss surrogate_nfet_freepdk45 l=5e-08 w=1.8e-07 scale_vth0={M366_vth0} scale_u0={M366_u0} scale_voff={M366_voff} * xwl_drv_0.xpnand2.mpnand2_nmos1
Xmos_367 xwl_drv_0.xpnand2.net1 dec_wl0 vss vss surrogate_nfet_freepdk45 l=5e-08 w=1.8e-07 scale_vth0={M367_vth0} scale_u0={M367_u0} scale_voff={M367_voff} * xwl_drv_0.xpnand2.mpnand2_nmos2
Xmos_368 wl0 xwl_drv_0.zb_int vdd vdd surrogate_pfet_freepdk45 l=5e-08 w=2.7e-07 scale_vth0={M368_vth0} scale_u0={M368_u0} scale_voff={M368_voff} * xwl_drv_0.xpinv.mpinv_pmos
Xmos_369 wl0 xwl_drv_0.zb_int vss vss surrogate_nfet_freepdk45 l=5e-08 w=9e-08 scale_vth0={M369_vth0} scale_u0={M369_u0} scale_voff={M369_voff} * xwl_drv_0.xpinv.mpinv_nmos
Xmos_370 xd_latch.db sa_q0 vdd vdd surrogate_pfet_freepdk45 l=5e-08 w=2.7e-07 scale_vth0={M370_vth0} scale_u0={M370_u0} scale_voff={M370_voff} * xd_latch.xinv1.mpinv_pmos
Xmos_371 xd_latch.db sa_q0 vss vss surrogate_nfet_freepdk45 l=5e-08 w=1.8e-07 scale_vth0={M371_vth0} scale_u0={M371_u0} scale_voff={M371_voff} * xd_latch.xinv1.mpinv_nmos
Xmos_372 xd_latch.int1 sa_q0 vdd vdd surrogate_pfet_freepdk45 l=5e-08 w=2.7e-07 scale_vth0={M372_vth0} scale_u0={M372_u0} scale_voff={M372_voff} * xd_latch.xnand1.mpnand2_pmos1
Xmos_373 xd_latch.int1 s_en vdd vdd surrogate_pfet_freepdk45 l=5e-08 w=2.7e-07 scale_vth0={M373_vth0} scale_u0={M373_u0} scale_voff={M373_voff} * xd_latch.xnand1.mpnand2_pmos2
Xmos_374 xd_latch.int1 s_en xd_latch.xnand1.net1 vss surrogate_nfet_freepdk45 l=5e-08 w=1.8e-07 scale_vth0={M374_vth0} scale_u0={M374_u0} scale_voff={M374_voff} * xd_latch.xnand1.mpnand2_nmos1
Xmos_375 xd_latch.xnand1.net1 sa_q0 vss vss surrogate_nfet_freepdk45 l=5e-08 w=1.8e-07 scale_vth0={M375_vth0} scale_u0={M375_u0} scale_voff={M375_voff} * xd_latch.xnand1.mpnand2_nmos2
Xmos_376 xd_latch.int2 xd_latch.db vdd vdd surrogate_pfet_freepdk45 l=5e-08 w=2.7e-07 scale_vth0={M376_vth0} scale_u0={M376_u0} scale_voff={M376_voff} * xd_latch.xnand2.mpnand2_pmos1
Xmos_377 xd_latch.int2 s_en vdd vdd surrogate_pfet_freepdk45 l=5e-08 w=2.7e-07 scale_vth0={M377_vth0} scale_u0={M377_u0} scale_voff={M377_voff} * xd_latch.xnand2.mpnand2_pmos2
Xmos_378 xd_latch.int2 s_en xd_latch.xnand2.net1 vss surrogate_nfet_freepdk45 l=5e-08 w=1.8e-07 scale_vth0={M378_vth0} scale_u0={M378_u0} scale_voff={M378_voff} * xd_latch.xnand2.mpnand2_nmos1
Xmos_379 xd_latch.xnand2.net1 xd_latch.db vss vss surrogate_nfet_freepdk45 l=5e-08 w=1.8e-07 scale_vth0={M379_vth0} scale_u0={M379_u0} scale_voff={M379_voff} * xd_latch.xnand2.mpnand2_nmos2
Xmos_380 out xd_latch.int1 vdd vdd surrogate_pfet_freepdk45 l=5e-08 w=2.7e-07 scale_vth0={M380_vth0} scale_u0={M380_u0} scale_voff={M380_voff} * xd_latch.xnand3.mpnand2_pmos1
Xmos_381 out out_b vdd vdd surrogate_pfet_freepdk45 l=5e-08 w=2.7e-07 scale_vth0={M381_vth0} scale_u0={M381_u0} scale_voff={M381_voff} * xd_latch.xnand3.mpnand2_pmos2
Xmos_382 out out_b xd_latch.xnand3.net1 vss surrogate_nfet_freepdk45 l=5e-08 w=1.8e-07 scale_vth0={M382_vth0} scale_u0={M382_u0} scale_voff={M382_voff} * xd_latch.xnand3.mpnand2_nmos1
Xmos_383 xd_latch.xnand3.net1 xd_latch.int1 vss vss surrogate_nfet_freepdk45 l=5e-08 w=1.8e-07 scale_vth0={M383_vth0} scale_u0={M383_u0} scale_voff={M383_voff} * xd_latch.xnand3.mpnand2_nmos2
Xmos_384 out_b xd_latch.int2 vdd vdd surrogate_pfet_freepdk45 l=5e-08 w=2.7e-07 scale_vth0={M384_vth0} scale_u0={M384_u0} scale_voff={M384_voff} * xd_latch.xnand4.mpnand2_pmos1
Xmos_385 out_b out vdd vdd surrogate_pfet_freepdk45 l=5e-08 w=2.7e-07 scale_vth0={M385_vth0} scale_u0={M385_u0} scale_voff={M385_voff} * xd_latch.xnand4.mpnand2_pmos2
Xmos_386 out_b out xd_latch.xnand4.net1 vss surrogate_nfet_freepdk45 l=5e-08 w=1.8e-07 scale_vth0={M386_vth0} scale_u0={M386_u0} scale_voff={M386_voff} * xd_latch.xnand4.mpnand2_nmos1
Xmos_387 xd_latch.xnand4.net1 xd_latch.int2 vss vss surrogate_nfet_freepdk45 l=5e-08 w=1.8e-07 scale_vth0={M387_vth0} scale_u0={M387_u0} scale_voff={M387_voff} * xd_latch.xnand4.mpnand2_nmos2
Xmos_388 bl0 pre vdd vdd surrogate_pfet_freepdk45 l=5e-08 w=1.35e-07 scale_vth0={M388_vth0} scale_u0={M388_u0} scale_voff={M388_voff} * xprecharge_0.m1
Xmos_389 blb0 pre vdd vdd surrogate_pfet_freepdk45 l=5e-08 w=1.35e-07 scale_vth0={M389_vth0} scale_u0={M389_u0} scale_voff={M389_voff} * xprecharge_0.m2
Xmos_390 bl0 pre blb0 vdd surrogate_pfet_freepdk45 l=5e-08 w=1.35e-07 scale_vth0={M390_vth0} scale_u0={M390_u0} scale_voff={M390_voff} * xprecharge_0.m3
Xmos_391 rbl pre vdd vdd surrogate_pfet_freepdk45 l=5e-08 w=1.35e-07 scale_vth0={M391_vth0} scale_u0={M391_u0} scale_voff={M391_voff} * xprecharge_rbl.m1
Xmos_392 rblb pre vdd vdd surrogate_pfet_freepdk45 l=5e-08 w=1.35e-07 scale_vth0={M392_vth0} scale_u0={M392_u0} scale_voff={M392_voff} * xprecharge_rbl.m2
Xmos_393 rbl pre rblb vdd surrogate_pfet_freepdk45 l=5e-08 w=1.35e-07 scale_vth0={M393_vth0} scale_u0={M393_u0} scale_voff={M393_voff} * xprecharge_rbl.m3
Xmos_394 sa_q0 sa_qb0 xsenseamp_0.net1 vss surrogate_nfet_freepdk45 l=5e-08 w=2.7e-07 scale_vth0={M394_vth0} scale_u0={M394_u0} scale_voff={M394_voff} * xsenseamp_0.m1
Xmos_395 sa_q0 sa_qb0 vdd vdd surrogate_pfet_freepdk45 l=5e-08 w=5.4e-07 scale_vth0={M395_vth0} scale_u0={M395_u0} scale_voff={M395_voff} * xsenseamp_0.m2
Xmos_396 sa_qb0 sa_q0 xsenseamp_0.net1 vss surrogate_nfet_freepdk45 l=5e-08 w=2.7e-07 scale_vth0={M396_vth0} scale_u0={M396_u0} scale_voff={M396_voff} * xsenseamp_0.m3
Xmos_397 sa_qb0 sa_q0 vdd vdd surrogate_pfet_freepdk45 l=5e-08 w=5.4e-07 scale_vth0={M397_vth0} scale_u0={M397_u0} scale_voff={M397_voff} * xsenseamp_0.m4
Xmos_398 sa_q0 s_en bl0 vdd surrogate_pfet_freepdk45 l=5e-08 w=7.2e-07 scale_vth0={M398_vth0} scale_u0={M398_u0} scale_voff={M398_voff} * xsenseamp_0.m5
Xmos_399 sa_qb0 s_en blb0 vdd surrogate_pfet_freepdk45 l=5e-08 w=7.2e-07 scale_vth0={M399_vth0} scale_u0={M399_u0} scale_voff={M399_voff} * xsenseamp_0.m6
Xmos_400 xsenseamp_0.net1 s_en vss vss surrogate_nfet_freepdk45 l=5e-08 w=2.7e-07 scale_vth0={M400_vth0} scale_u0={M400_u0} scale_voff={M400_voff} * xsenseamp_0.m7
VADDR_0 A0 VSS 0
VCLK clk VSS DC 0 PULSE(0 1.0 3e-09 1e-10 1e-10 5e-09 1e-08)
VCSB csb VSS DC 0 PULSE(0 1.0 1e-09 1e-10 1e-10 1e-09 1e-08)
VWEB web VSS DC 0 PULSE(0 1.0 2e-09 1e-10 1e-10 9.8e-09 1e-08)

.ic v(xsram_6t_core_1x1.xsram_6t_cell_0_0.q)=0 v(xsram_6t_core_1x1.xsram_6t_cell_0_0.qb)=1 v(bl0)=0 v(blb0)=0 v(out)=0 v(rbl)=0 v(a_dff0)=0 v(we)=1 v(cs_bar)=1

.control
* OpenYield read delay
tran 0.01n 12n uic
meas tran read_error FIND v(SA_Q0) AT=11n
quit
.endc

.end
