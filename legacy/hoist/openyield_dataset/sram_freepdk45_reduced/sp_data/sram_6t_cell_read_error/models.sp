* Automatically generated baseline models
.model m_local_4 pmos level=8 version=3.3.0 vth0={M4_vth0} u0={M4_u0} voff={M4_voff}
.model m_local_5 pmos level=8 version=3.3.0 vth0={M5_vth0} u0={M5_u0} voff={M5_voff}
.model m_local_0 nmos level=8 version=3.3.0 vth0={M0_vth0} u0={M0_u0} voff={M0_voff}
.model m_local_1 nmos level=8 version=3.3.0 vth0={M1_vth0} u0={M1_u0} voff={M1_voff}
.model m_local_2 nmos level=8 version=3.3.0 vth0={M2_vth0} u0={M2_u0} voff={M2_voff}
.model m_local_3 nmos level=8 version=3.3.0 vth0={M3_vth0} u0={M3_u0} voff={M3_voff}
