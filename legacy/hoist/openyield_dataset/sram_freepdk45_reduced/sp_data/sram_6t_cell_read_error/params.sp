* Current baseline sample
.param M4_vth0 = 9.078971385956e-01
.param M4_u0 = 1.013744035363e+00
.param M4_voff = 1.007932093740e+00
.param M5_vth0 = 1.079417061806e+00
.param M5_u0 = 1.197736155987e+00
.param M5_voff = 1.106908631325e+00
.param M0_vth0 = 7.736601591110e-01
.param M0_u0 = 1.109773683548e+00
.param M0_voff = 1.046332594752e+00
.param M1_vth0 = 9.408164143562e-01
.param M1_u0 = 9.483732998371e-01
.param M1_voff = 1.032196295261e+00
.param M2_vth0 = 1.044469392300e+00
.param M2_u0 = 8.151472806931e-01
.param M2_voff = 1.101424086094e+00
.param M3_vth0 = 1.145266664028e+00
.param M3_u0 = 1.148941397667e+00
.param M3_voff = 9.811751872301e-01
