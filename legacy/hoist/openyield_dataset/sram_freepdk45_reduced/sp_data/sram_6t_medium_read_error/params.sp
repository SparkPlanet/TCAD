* Current baseline sample
.param M4_vth0 = 9.261607663036e-01
.param M4_u0 = 9.845685383116e-01
.param M4_voff = 9.924855233063e-01
.param M5_vth0 = 9.859543846724e-01
.param M5_u0 = 9.652971971902e-01
.param M5_voff = 9.407212864514e-01
.param M6_vth0 = 9.862695362339e-01
.param M6_u0 = 9.360962627134e-01
.param M6_voff = 1.076855820692e+00
.param M7_vth0 = 9.506953284494e-01
.param M7_u0 = 9.760557906511e-01
.param M7_voff = 9.008443490641e-01
.param M8_vth0 = 1.055292453481e+00
.param M8_u0 = 9.038655727768e-01
.param M8_voff = 9.451049638276e-01
.param M9_vth0 = 9.500970926214e-01
.param M9_u0 = 1.061898810998e+00
.param M9_voff = 9.888926070244e-01
.param M11_vth0 = 9.771629729727e-01
.param M11_u0 = 1.026122975478e+00
.param M11_voff = 9.949254579981e-01
.param M13_vth0 = 9.668315955514e-01
.param M13_u0 = 1.001536111981e+00
.param M13_voff = 1.074370655010e+00
.param M15_vth0 = 1.022241313921e+00
.param M15_u0 = 9.727863625989e-01
.param M15_voff = 9.773964229058e-01
.param M17_vth0 = 9.702350510549e-01
.param M17_u0 = 1.065927485434e+00
.param M17_voff = 9.845694361567e-01
.param M19_vth0 = 9.304898920894e-01
.param M19_u0 = 1.049415090722e+00
.param M19_voff = 9.816748448247e-01
.param M21_vth0 = 8.596981640457e-01
.param M21_u0 = 9.390388107006e-01
.param M21_voff = 1.002307542908e+00
.param M23_vth0 = 1.027583157593e+00
.param M23_u0 = 1.085750399422e+00
.param M23_voff = 9.481764042864e-01
.param M25_vth0 = 1.085169851081e+00
.param M25_u0 = 9.183769193539e-01
.param M25_voff = 9.540896143475e-01
.param M27_vth0 = 1.082752744688e+00
.param M27_u0 = 1.070081765059e+00
.param M27_voff = 1.022810003875e+00
.param M29_vth0 = 1.037730335166e+00
.param M29_u0 = 9.857961383300e-01
.param M29_voff = 1.061040136792e+00
.param M31_vth0 = 1.030277616661e+00
.param M31_u0 = 1.015350730881e+00
.param M31_voff = 1.009238735419e+00
.param M33_vth0 = 1.010887795282e+00
.param M33_u0 = 9.523938620161e-01
.param M33_voff = 9.809871041267e-01
.param M35_vth0 = 1.073917196993e+00
.param M35_u0 = 9.644683430940e-01
.param M35_voff = 9.484994949752e-01
.param M37_vth0 = 1.040964358753e+00
.param M37_u0 = 9.470996645535e-01
.param M37_voff = 1.000172768652e+00
.param M39_vth0 = 9.980454248633e-01
.param M39_u0 = 9.643113335301e-01
.param M39_voff = 9.704340998023e-01
.param M41_vth0 = 1.087334599047e+00
.param M41_u0 = 1.020414922569e+00
.param M41_voff = 9.939752693751e-01
.param M43_vth0 = 1.005394209349e+00
.param M43_u0 = 1.002410483062e+00
.param M43_voff = 1.016985169636e+00
.param M45_vth0 = 1.043088509111e+00
.param M45_u0 = 1.022463310187e+00
.param M45_voff = 1.065654412679e+00
.param M47_vth0 = 1.020139126993e+00
.param M47_u0 = 1.032322818873e+00
.param M47_voff = 9.986048278811e-01
.param M49_vth0 = 9.729597575190e-01
.param M49_u0 = 1.037072710924e+00
.param M49_voff = 9.878376191956e-01
.param M51_vth0 = 8.978102112030e-01
.param M51_u0 = 9.677794908178e-01
.param M51_voff = 9.351245755342e-01
.param M53_vth0 = 1.023491336806e+00
.param M53_u0 = 9.416517070943e-01
.param M53_voff = 1.030819507705e+00
.param M55_vth0 = 9.568059986583e-01
.param M55_u0 = 1.033756105233e+00
.param M55_voff = 9.595085995807e-01
.param M57_vth0 = 9.726658211330e-01
.param M57_u0 = 9.485208589242e-01
.param M57_voff = 9.725271008168e-01
.param M59_vth0 = 9.235375240223e-01
.param M59_u0 = 1.003453251097e+00
.param M59_voff = 1.003880730462e+00
.param M61_vth0 = 1.017071544070e+00
.param M61_u0 = 1.011325515323e+00
.param M61_voff = 1.006710179578e+00
.param M63_vth0 = 9.514163046936e-01
.param M63_u0 = 9.358615385685e-01
.param M63_voff = 9.919723308408e-01
.param M65_vth0 = 1.027420736237e+00
.param M65_u0 = 1.014338096107e+00
.param M65_voff = 1.020780718000e+00
.param M67_vth0 = 1.057105515178e+00
.param M67_u0 = 1.048160940708e+00
.param M67_voff = 9.960950758017e-01
.param M69_vth0 = 9.399582254594e-01
.param M69_u0 = 1.085660576153e+00
.param M69_voff = 1.004784843188e+00
.param M71_vth0 = 9.628681103277e-01
.param M71_u0 = 9.884639183990e-01
.param M71_voff = 9.824866868585e-01
.param M73_vth0 = 1.037945391340e+00
.param M73_u0 = 9.064031997038e-01
.param M73_voff = 9.641003407007e-01
.param M75_vth0 = 9.838373755673e-01
.param M75_u0 = 1.048533132730e+00
.param M75_voff = 1.054855804887e+00
.param M77_vth0 = 9.254318495817e-01
.param M77_u0 = 9.453390527618e-01
.param M77_voff = 9.948548766533e-01
.param M79_vth0 = 9.534784582037e-01
.param M79_u0 = 9.666821909117e-01
.param M79_voff = 1.030281340455e+00
.param M0_vth0 = 1.059448190122e+00
.param M0_u0 = 8.983672480712e-01
.param M0_voff = 9.427673616604e-01
.param M1_vth0 = 1.023790821706e+00
.param M1_u0 = 9.256205962446e-01
.param M1_voff = 1.051965807508e+00
.param M2_vth0 = 1.017987080348e+00
.param M2_u0 = 1.124465530596e+00
.param M2_voff = 1.051872073952e+00
.param M3_vth0 = 9.781387839251e-01
.param M3_u0 = 9.521872952503e-01
.param M3_voff = 9.410280264780e-01
.param M10_vth0 = 9.734752528296e-01
.param M10_u0 = 9.463212809409e-01
.param M10_voff = 9.778774408877e-01
.param M12_vth0 = 1.030425108802e+00
.param M12_u0 = 9.995337603100e-01
.param M12_voff = 9.975749656076e-01
.param M14_vth0 = 9.498042463004e-01
.param M14_u0 = 9.519395616503e-01
.param M14_voff = 9.826931282727e-01
.param M16_vth0 = 9.853550764430e-01
.param M16_u0 = 9.534687748929e-01
.param M16_voff = 1.067747820765e+00
.param M18_vth0 = 1.067529964366e+00
.param M18_u0 = 9.119617937888e-01
.param M18_voff = 1.011304291949e+00
.param M20_vth0 = 1.032680218983e+00
.param M20_u0 = 9.605127656243e-01
.param M20_voff = 1.093377324969e+00
.param M22_vth0 = 1.033053919183e+00
.param M22_u0 = 1.028443031066e+00
.param M22_voff = 1.157684780623e+00
.param M24_vth0 = 1.081357010636e+00
.param M24_u0 = 1.011802383684e+00
.param M24_voff = 9.194908081895e-01
.param M26_vth0 = 1.010256246810e+00
.param M26_u0 = 9.674412403788e-01
.param M26_voff = 1.039867451109e+00
.param M28_vth0 = 1.041229219958e+00
.param M28_u0 = 9.847677106743e-01
.param M28_voff = 9.884025843018e-01
.param M30_vth0 = 1.023761818120e+00
.param M30_u0 = 9.895209943767e-01
.param M30_voff = 1.102722173787e+00
.param M32_vth0 = 9.184098055679e-01
.param M32_u0 = 1.048851679122e+00
.param M32_voff = 1.028216154707e+00
.param M34_vth0 = 9.363436433689e-01
.param M34_u0 = 8.952671039314e-01
.param M34_voff = 9.754517717945e-01
.param M36_vth0 = 1.020611129626e+00
.param M36_u0 = 1.003117275096e+00
.param M36_voff = 1.104574265708e+00
.param M38_vth0 = 9.475287704239e-01
.param M38_u0 = 1.019923894696e+00
.param M38_voff = 9.839675235894e-01
.param M40_vth0 = 1.028070103572e+00
.param M40_u0 = 9.880919747483e-01
.param M40_voff = 9.709366369657e-01
.param M42_vth0 = 1.052533318154e+00
.param M42_u0 = 1.042383233494e+00
.param M42_voff = 1.045487416738e+00
.param M44_vth0 = 9.987171671339e-01
.param M44_u0 = 1.029693294100e+00
.param M44_voff = 1.021874182599e+00
.param M46_vth0 = 1.073329210587e+00
.param M46_u0 = 1.111805328572e+00
.param M46_voff = 9.381300740124e-01
.param M48_vth0 = 9.812171020371e-01
.param M48_u0 = 1.072738751041e+00
.param M48_voff = 9.435960950648e-01
.param M50_vth0 = 1.006984807859e+00
.param M50_u0 = 1.017440879448e+00
.param M50_voff = 1.016467293945e+00
.param M52_vth0 = 1.020204552070e+00
.param M52_u0 = 9.750853562110e-01
.param M52_voff = 9.581359537285e-01
.param M54_vth0 = 9.984700629298e-01
.param M54_u0 = 1.078812691949e+00
.param M54_voff = 9.615005952395e-01
.param M56_vth0 = 1.052990974700e+00
.param M56_u0 = 9.712641529766e-01
.param M56_voff = 1.016678697607e+00
.param M58_vth0 = 9.549527826669e-01
.param M58_u0 = 1.095455721802e+00
.param M58_voff = 1.069960013508e+00
.param M60_vth0 = 1.006958800708e+00
.param M60_u0 = 1.064152311058e+00
.param M60_voff = 1.024149120192e+00
.param M62_vth0 = 9.586615853467e-01
.param M62_u0 = 9.478798965106e-01
.param M62_voff = 1.076781564299e+00
.param M64_vth0 = 1.040901742518e+00
.param M64_u0 = 8.773562677069e-01
.param M64_voff = 1.046800282094e+00
.param M66_vth0 = 9.029268640137e-01
.param M66_u0 = 1.040435306581e+00
.param M66_voff = 1.035872860134e+00
.param M68_vth0 = 1.049870478032e+00
.param M68_u0 = 9.815846821179e-01
.param M68_voff = 1.020444084983e+00
.param M70_vth0 = 1.024982430880e+00
.param M70_u0 = 9.627954407202e-01
.param M70_voff = 1.049160917378e+00
.param M72_vth0 = 1.035892916124e+00
.param M72_u0 = 9.816468468005e-01
.param M72_voff = 9.514944826472e-01
.param M74_vth0 = 9.242859934653e-01
.param M74_u0 = 1.003268568865e+00
.param M74_voff = 9.541461692838e-01
.param M76_vth0 = 1.013975014413e+00
.param M76_u0 = 1.037706637442e+00
.param M76_voff = 9.614936356303e-01
.param M78_vth0 = 1.083759700052e+00
.param M78_u0 = 9.876694377328e-01
.param M78_voff = 9.654181285652e-01
.param M80_vth0 = 1.011880254405e+00
.param M80_u0 = 9.623338634902e-01
.param M80_voff = 9.818411402944e-01
