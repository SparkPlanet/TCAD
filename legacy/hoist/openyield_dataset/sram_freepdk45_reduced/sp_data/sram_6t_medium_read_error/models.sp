* Automatically generated baseline models
.model m_local_4 pmos level=8 version=3.3.0 vth0={M4_vth0} u0={M4_u0} voff={M4_voff}
.model m_local_5 pmos level=8 version=3.3.0 vth0={M5_vth0} u0={M5_u0} voff={M5_voff}
.model m_local_6 pmos level=8 version=3.3.0 vth0={M6_vth0} u0={M6_u0} voff={M6_voff}
.model m_local_7 pmos level=8 version=3.3.0 vth0={M7_vth0} u0={M7_u0} voff={M7_voff}
.model m_local_8 pmos level=8 version=3.3.0 vth0={M8_vth0} u0={M8_u0} voff={M8_voff}
.model m_local_9 pmos level=8 version=3.3.0 vth0={M9_vth0} u0={M9_u0} voff={M9_voff}
.model m_local_11 pmos level=8 version=3.3.0 vth0={M11_vth0} u0={M11_u0} voff={M11_voff}
.model m_local_13 pmos level=8 version=3.3.0 vth0={M13_vth0} u0={M13_u0} voff={M13_voff}
.model m_local_15 pmos level=8 version=3.3.0 vth0={M15_vth0} u0={M15_u0} voff={M15_voff}
.model m_local_17 pmos level=8 version=3.3.0 vth0={M17_vth0} u0={M17_u0} voff={M17_voff}
.model m_local_19 pmos level=8 version=3.3.0 vth0={M19_vth0} u0={M19_u0} voff={M19_voff}
.model m_local_21 pmos level=8 version=3.3.0 vth0={M21_vth0} u0={M21_u0} voff={M21_voff}
.model m_local_23 pmos level=8 version=3.3.0 vth0={M23_vth0} u0={M23_u0} voff={M23_voff}
.model m_local_25 pmos level=8 version=3.3.0 vth0={M25_vth0} u0={M25_u0} voff={M25_voff}
.model m_local_27 pmos level=8 version=3.3.0 vth0={M27_vth0} u0={M27_u0} voff={M27_voff}
.model m_local_29 pmos level=8 version=3.3.0 vth0={M29_vth0} u0={M29_u0} voff={M29_voff}
.model m_local_31 pmos level=8 version=3.3.0 vth0={M31_vth0} u0={M31_u0} voff={M31_voff}
.model m_local_33 pmos level=8 version=3.3.0 vth0={M33_vth0} u0={M33_u0} voff={M33_voff}
.model m_local_35 pmos level=8 version=3.3.0 vth0={M35_vth0} u0={M35_u0} voff={M35_voff}
.model m_local_37 pmos level=8 version=3.3.0 vth0={M37_vth0} u0={M37_u0} voff={M37_voff}
.model m_local_39 pmos level=8 version=3.3.0 vth0={M39_vth0} u0={M39_u0} voff={M39_voff}
.model m_local_41 pmos level=8 version=3.3.0 vth0={M41_vth0} u0={M41_u0} voff={M41_voff}
.model m_local_43 pmos level=8 version=3.3.0 vth0={M43_vth0} u0={M43_u0} voff={M43_voff}
.model m_local_45 pmos level=8 version=3.3.0 vth0={M45_vth0} u0={M45_u0} voff={M45_voff}
.model m_local_47 pmos level=8 version=3.3.0 vth0={M47_vth0} u0={M47_u0} voff={M47_voff}
.model m_local_49 pmos level=8 version=3.3.0 vth0={M49_vth0} u0={M49_u0} voff={M49_voff}
.model m_local_51 pmos level=8 version=3.3.0 vth0={M51_vth0} u0={M51_u0} voff={M51_voff}
.model m_local_53 pmos level=8 version=3.3.0 vth0={M53_vth0} u0={M53_u0} voff={M53_voff}
.model m_local_55 pmos level=8 version=3.3.0 vth0={M55_vth0} u0={M55_u0} voff={M55_voff}
.model m_local_57 pmos level=8 version=3.3.0 vth0={M57_vth0} u0={M57_u0} voff={M57_voff}
.model m_local_59 pmos level=8 version=3.3.0 vth0={M59_vth0} u0={M59_u0} voff={M59_voff}
.model m_local_61 pmos level=8 version=3.3.0 vth0={M61_vth0} u0={M61_u0} voff={M61_voff}
.model m_local_63 pmos level=8 version=3.3.0 vth0={M63_vth0} u0={M63_u0} voff={M63_voff}
.model m_local_65 pmos level=8 version=3.3.0 vth0={M65_vth0} u0={M65_u0} voff={M65_voff}
.model m_local_67 pmos level=8 version=3.3.0 vth0={M67_vth0} u0={M67_u0} voff={M67_voff}
.model m_local_69 pmos level=8 version=3.3.0 vth0={M69_vth0} u0={M69_u0} voff={M69_voff}
.model m_local_71 pmos level=8 version=3.3.0 vth0={M71_vth0} u0={M71_u0} voff={M71_voff}
.model m_local_73 pmos level=8 version=3.3.0 vth0={M73_vth0} u0={M73_u0} voff={M73_voff}
.model m_local_75 pmos level=8 version=3.3.0 vth0={M75_vth0} u0={M75_u0} voff={M75_voff}
.model m_local_77 pmos level=8 version=3.3.0 vth0={M77_vth0} u0={M77_u0} voff={M77_voff}
.model m_local_79 pmos level=8 version=3.3.0 vth0={M79_vth0} u0={M79_u0} voff={M79_voff}
.model m_local_0 nmos level=8 version=3.3.0 vth0={M0_vth0} u0={M0_u0} voff={M0_voff}
.model m_local_1 nmos level=8 version=3.3.0 vth0={M1_vth0} u0={M1_u0} voff={M1_voff}
.model m_local_2 nmos level=8 version=3.3.0 vth0={M2_vth0} u0={M2_u0} voff={M2_voff}
.model m_local_3 nmos level=8 version=3.3.0 vth0={M3_vth0} u0={M3_u0} voff={M3_voff}
.model m_local_10 nmos level=8 version=3.3.0 vth0={M10_vth0} u0={M10_u0} voff={M10_voff}
.model m_local_12 nmos level=8 version=3.3.0 vth0={M12_vth0} u0={M12_u0} voff={M12_voff}
.model m_local_14 nmos level=8 version=3.3.0 vth0={M14_vth0} u0={M14_u0} voff={M14_voff}
.model m_local_16 nmos level=8 version=3.3.0 vth0={M16_vth0} u0={M16_u0} voff={M16_voff}
.model m_local_18 nmos level=8 version=3.3.0 vth0={M18_vth0} u0={M18_u0} voff={M18_voff}
.model m_local_20 nmos level=8 version=3.3.0 vth0={M20_vth0} u0={M20_u0} voff={M20_voff}
.model m_local_22 nmos level=8 version=3.3.0 vth0={M22_vth0} u0={M22_u0} voff={M22_voff}
.model m_local_24 nmos level=8 version=3.3.0 vth0={M24_vth0} u0={M24_u0} voff={M24_voff}
.model m_local_26 nmos level=8 version=3.3.0 vth0={M26_vth0} u0={M26_u0} voff={M26_voff}
.model m_local_28 nmos level=8 version=3.3.0 vth0={M28_vth0} u0={M28_u0} voff={M28_voff}
.model m_local_30 nmos level=8 version=3.3.0 vth0={M30_vth0} u0={M30_u0} voff={M30_voff}
.model m_local_32 nmos level=8 version=3.3.0 vth0={M32_vth0} u0={M32_u0} voff={M32_voff}
.model m_local_34 nmos level=8 version=3.3.0 vth0={M34_vth0} u0={M34_u0} voff={M34_voff}
.model m_local_36 nmos level=8 version=3.3.0 vth0={M36_vth0} u0={M36_u0} voff={M36_voff}
.model m_local_38 nmos level=8 version=3.3.0 vth0={M38_vth0} u0={M38_u0} voff={M38_voff}
.model m_local_40 nmos level=8 version=3.3.0 vth0={M40_vth0} u0={M40_u0} voff={M40_voff}
.model m_local_42 nmos level=8 version=3.3.0 vth0={M42_vth0} u0={M42_u0} voff={M42_voff}
.model m_local_44 nmos level=8 version=3.3.0 vth0={M44_vth0} u0={M44_u0} voff={M44_voff}
.model m_local_46 nmos level=8 version=3.3.0 vth0={M46_vth0} u0={M46_u0} voff={M46_voff}
.model m_local_48 nmos level=8 version=3.3.0 vth0={M48_vth0} u0={M48_u0} voff={M48_voff}
.model m_local_50 nmos level=8 version=3.3.0 vth0={M50_vth0} u0={M50_u0} voff={M50_voff}
.model m_local_52 nmos level=8 version=3.3.0 vth0={M52_vth0} u0={M52_u0} voff={M52_voff}
.model m_local_54 nmos level=8 version=3.3.0 vth0={M54_vth0} u0={M54_u0} voff={M54_voff}
.model m_local_56 nmos level=8 version=3.3.0 vth0={M56_vth0} u0={M56_u0} voff={M56_voff}
.model m_local_58 nmos level=8 version=3.3.0 vth0={M58_vth0} u0={M58_u0} voff={M58_voff}
.model m_local_60 nmos level=8 version=3.3.0 vth0={M60_vth0} u0={M60_u0} voff={M60_voff}
.model m_local_62 nmos level=8 version=3.3.0 vth0={M62_vth0} u0={M62_u0} voff={M62_voff}
.model m_local_64 nmos level=8 version=3.3.0 vth0={M64_vth0} u0={M64_u0} voff={M64_voff}
.model m_local_66 nmos level=8 version=3.3.0 vth0={M66_vth0} u0={M66_u0} voff={M66_voff}
.model m_local_68 nmos level=8 version=3.3.0 vth0={M68_vth0} u0={M68_u0} voff={M68_voff}
.model m_local_70 nmos level=8 version=3.3.0 vth0={M70_vth0} u0={M70_u0} voff={M70_voff}
.model m_local_72 nmos level=8 version=3.3.0 vth0={M72_vth0} u0={M72_u0} voff={M72_voff}
.model m_local_74 nmos level=8 version=3.3.0 vth0={M74_vth0} u0={M74_u0} voff={M74_voff}
.model m_local_76 nmos level=8 version=3.3.0 vth0={M76_vth0} u0={M76_u0} voff={M76_voff}
.model m_local_78 nmos level=8 version=3.3.0 vth0={M78_vth0} u0={M78_u0} voff={M78_voff}
.model m_local_80 nmos level=8 version=3.3.0 vth0={M80_vth0} u0={M80_u0} voff={M80_voff}
